* NGSPICE file created from adc_top.ext - technology: sky130A

* Black-box entry subcircuit for sky130_fd_sc_hd__decap_4 abstract view
.subckt sky130_fd_sc_hd__decap_4 VGND VNB VPB VPWR
.ends

* Black-box entry subcircuit for sky130_fd_sc_hd__dfrtp_1 abstract view
.subckt sky130_fd_sc_hd__dfrtp_1 CLK D RESET_B VGND VNB VPB VPWR Q
.ends

* Black-box entry subcircuit for sky130_fd_sc_hd__inv_2 abstract view
.subckt sky130_fd_sc_hd__inv_2 A VGND VNB VPB VPWR Y
.ends

* Black-box entry subcircuit for sky130_ef_sc_hd__decap_12 abstract view
.subckt sky130_ef_sc_hd__decap_12 VPWR VGND VPB VNB
.ends

* Black-box entry subcircuit for sky130_fd_sc_hd__nand2_1 abstract view
.subckt sky130_fd_sc_hd__nand2_1 A B VGND VNB VPB VPWR Y
.ends

* Black-box entry subcircuit for sky130_fd_sc_hd__and2_1 abstract view
.subckt sky130_fd_sc_hd__and2_1 A B VGND VNB VPB VPWR X
.ends

* Black-box entry subcircuit for sky130_fd_sc_hd__decap_8 abstract view
.subckt sky130_fd_sc_hd__decap_8 VGND VNB VPB VPWR
.ends

* Black-box entry subcircuit for sky130_fd_sc_hd__o21a_1 abstract view
.subckt sky130_fd_sc_hd__o21a_1 A1 A2 B1 VGND VNB VPB VPWR X
.ends

* Black-box entry subcircuit for sky130_fd_sc_hd__decap_3 abstract view
.subckt sky130_fd_sc_hd__decap_3 VGND VNB VPB VPWR
.ends

* Black-box entry subcircuit for sky130_fd_sc_hd__mux2_1 abstract view
.subckt sky130_fd_sc_hd__mux2_1 A0 A1 S VGND VNB VPB VPWR X
.ends

* Black-box entry subcircuit for sky130_fd_sc_hd__fill_1 abstract view
.subckt sky130_fd_sc_hd__fill_1 VGND VNB VPB VPWR
.ends

* Black-box entry subcircuit for sky130_fd_sc_hd__dlygate4sd3_1 abstract view
.subckt sky130_fd_sc_hd__dlygate4sd3_1 A VGND VNB VPB VPWR X
.ends

* Black-box entry subcircuit for sky130_fd_sc_hd__decap_6 abstract view
.subckt sky130_fd_sc_hd__decap_6 VGND VNB VPB VPWR
.ends

* Black-box entry subcircuit for sky130_fd_sc_hd__buf_2 abstract view
.subckt sky130_fd_sc_hd__buf_2 A VGND VNB VPB VPWR X
.ends

* Black-box entry subcircuit for sky130_fd_sc_hd__tapvpwrvgnd_1 abstract view
.subckt sky130_fd_sc_hd__tapvpwrvgnd_1 VGND VPWR
.ends

* Black-box entry subcircuit for sky130_fd_sc_hd__nor2_1 abstract view
.subckt sky130_fd_sc_hd__nor2_1 A B VGND VNB VPB VPWR Y
.ends

* Black-box entry subcircuit for sky130_fd_sc_hd__fill_2 abstract view
.subckt sky130_fd_sc_hd__fill_2 VGND VNB VPB VPWR
.ends

* Black-box entry subcircuit for sky130_fd_sc_hd__and3_1 abstract view
.subckt sky130_fd_sc_hd__and3_1 A B C VGND VNB VPB VPWR X
.ends

* Black-box entry subcircuit for sky130_fd_sc_hd__a2bb2o_1 abstract view
.subckt sky130_fd_sc_hd__a2bb2o_1 A1_N A2_N B1 B2 VGND VNB VPB VPWR X
.ends

* Black-box entry subcircuit for sky130_fd_sc_hd__a21oi_1 abstract view
.subckt sky130_fd_sc_hd__a21oi_1 A1 A2 B1 VGND VNB VPB VPWR Y
.ends

* Black-box entry subcircuit for sky130_fd_sc_hd__o21ai_1 abstract view
.subckt sky130_fd_sc_hd__o21ai_1 A1 A2 B1 VGND VNB VPB VPWR Y
.ends

* Black-box entry subcircuit for sky130_fd_sc_hd__dfrtp_4 abstract view
.subckt sky130_fd_sc_hd__dfrtp_4 CLK D RESET_B VGND VNB VPB VPWR Q
.ends

* Black-box entry subcircuit for sky130_fd_sc_hd__xor2_1 abstract view
.subckt sky130_fd_sc_hd__xor2_1 A B VGND VNB VPB VPWR X
.ends

* Black-box entry subcircuit for sky130_fd_sc_hd__a21boi_1 abstract view
.subckt sky130_fd_sc_hd__a21boi_1 A1 A2 B1_N VGND VNB VPB VPWR Y
.ends

* Black-box entry subcircuit for sky130_fd_sc_hd__o22a_1 abstract view
.subckt sky130_fd_sc_hd__o22a_1 A1 A2 B1 B2 VGND VNB VPB VPWR X
.ends

* Black-box entry subcircuit for sky130_fd_sc_hd__clkinvlp_4 abstract view
.subckt sky130_fd_sc_hd__clkinvlp_4 A VGND VNB VPB VPWR Y
.ends

* Black-box entry subcircuit for sky130_fd_sc_hd__a22oi_1 abstract view
.subckt sky130_fd_sc_hd__a22oi_1 A1 A2 B1 B2 VGND VNB VPB VPWR Y
.ends

* Black-box entry subcircuit for sky130_fd_sc_hd__bufinv_16 abstract view
.subckt sky130_fd_sc_hd__bufinv_16 A VGND VNB VPB VPWR Y
.ends

* Black-box entry subcircuit for sky130_fd_sc_hd__nand2b_2 abstract view
.subckt sky130_fd_sc_hd__nand2b_2 A_N B VGND VNB VPB VPWR Y
.ends

* Black-box entry subcircuit for sky130_fd_sc_hd__or3_1 abstract view
.subckt sky130_fd_sc_hd__or3_1 A B C VGND VNB VPB VPWR X
.ends

* Black-box entry subcircuit for sky130_fd_sc_hd__or4_1 abstract view
.subckt sky130_fd_sc_hd__or4_1 A B C D VGND VNB VPB VPWR X
.ends

* Black-box entry subcircuit for sky130_fd_sc_hd__nand2_2 abstract view
.subckt sky130_fd_sc_hd__nand2_2 A B VGND VNB VPB VPWR Y
.ends

* Black-box entry subcircuit for sky130_fd_sc_hd__and4_1 abstract view
.subckt sky130_fd_sc_hd__and4_1 A B C D VGND VNB VPB VPWR X
.ends

* Black-box entry subcircuit for sky130_fd_sc_hd__clkbuf_4 abstract view
.subckt sky130_fd_sc_hd__clkbuf_4 A VGND VNB VPB VPWR X
.ends

* Black-box entry subcircuit for sky130_fd_sc_hd__clkbuf_16 abstract view
.subckt sky130_fd_sc_hd__clkbuf_16 A VGND VNB VPB VPWR X
.ends

* Black-box entry subcircuit for sky130_fd_sc_hd__dlymetal6s2s_1 abstract view
.subckt sky130_fd_sc_hd__dlymetal6s2s_1 A VGND VNB VPB VPWR X
.ends

* Black-box entry subcircuit for sky130_fd_sc_hd__clkbuf_2 abstract view
.subckt sky130_fd_sc_hd__clkbuf_2 A VGND VNB VPB VPWR X
.ends

* Black-box entry subcircuit for sky130_fd_sc_hd__nor3_1 abstract view
.subckt sky130_fd_sc_hd__nor3_1 A B C VGND VNB VPB VPWR Y
.ends

* Black-box entry subcircuit for sky130_fd_sc_hd__or2_1 abstract view
.subckt sky130_fd_sc_hd__or2_1 A B VGND VNB VPB VPWR X
.ends

* Black-box entry subcircuit for sky130_fd_sc_hd__buf_4 abstract view
.subckt sky130_fd_sc_hd__buf_4 A VGND VNB VPB VPWR X
.ends

* Black-box entry subcircuit for sky130_fd_sc_hd__buf_1 abstract view
.subckt sky130_fd_sc_hd__buf_1 A VGND VNB VPB VPWR X
.ends

* Black-box entry subcircuit for sky130_fd_sc_hd__clkbuf_1 abstract view
.subckt sky130_fd_sc_hd__clkbuf_1 A VGND VNB VPB VPWR X
.ends

* Black-box entry subcircuit for sky130_fd_sc_hd__xor2_2 abstract view
.subckt sky130_fd_sc_hd__xor2_2 A B VGND VNB VPB VPWR X
.ends

* Black-box entry subcircuit for sky130_fd_sc_hd__a31o_1 abstract view
.subckt sky130_fd_sc_hd__a31o_1 A1 A2 A3 B1 VGND VNB VPB VPWR X
.ends

* Black-box entry subcircuit for sky130_fd_sc_hd__o31a_1 abstract view
.subckt sky130_fd_sc_hd__o31a_1 A1 A2 A3 B1 VGND VNB VPB VPWR X
.ends

* Black-box entry subcircuit for sky130_fd_sc_hd__a21bo_1 abstract view
.subckt sky130_fd_sc_hd__a21bo_1 A1 A2 B1_N VGND VNB VPB VPWR X
.ends

* Black-box entry subcircuit for sky130_fd_sc_hd__o2bb2a_1 abstract view
.subckt sky130_fd_sc_hd__o2bb2a_1 A1_N A2_N B1 B2 VGND VNB VPB VPWR X
.ends

* Black-box entry subcircuit for sky130_fd_sc_hd__a2111o_1 abstract view
.subckt sky130_fd_sc_hd__a2111o_1 A1 A2 B1 C1 D1 VGND VNB VPB VPWR X
.ends

* Black-box entry subcircuit for sky130_fd_sc_hd__nand2b_1 abstract view
.subckt sky130_fd_sc_hd__nand2b_1 A_N B VGND VNB VPB VPWR Y
.ends

* Black-box entry subcircuit for sky130_fd_sc_hd__a211o_1 abstract view
.subckt sky130_fd_sc_hd__a211o_1 A1 A2 B1 C1 VGND VNB VPB VPWR X
.ends

* Black-box entry subcircuit for sky130_fd_sc_hd__a22o_1 abstract view
.subckt sky130_fd_sc_hd__a22o_1 A1 A2 B1 B2 VGND VNB VPB VPWR X
.ends

* Black-box entry subcircuit for sky130_fd_sc_hd__o211a_1 abstract view
.subckt sky130_fd_sc_hd__o211a_1 A1 A2 B1 C1 VGND VNB VPB VPWR X
.ends

* Black-box entry subcircuit for sky130_fd_sc_hd__o21ba_1 abstract view
.subckt sky130_fd_sc_hd__o21ba_1 A1 A2 B1_N VGND VNB VPB VPWR X
.ends

* Black-box entry subcircuit for sky130_fd_sc_hd__and4bb_1 abstract view
.subckt sky130_fd_sc_hd__and4bb_1 A_N B_N C D VGND VNB VPB VPWR X
.ends

* Black-box entry subcircuit for sky130_fd_sc_hd__or3b_1 abstract view
.subckt sky130_fd_sc_hd__or3b_1 A B C_N VGND VNB VPB VPWR X
.ends

* Black-box entry subcircuit for sky130_fd_sc_hd__o2111ai_2 abstract view
.subckt sky130_fd_sc_hd__o2111ai_2 A1 A2 B1 C1 D1 VGND VNB VPB VPWR Y
.ends

* Black-box entry subcircuit for sky130_fd_sc_hd__nor3b_1 abstract view
.subckt sky130_fd_sc_hd__nor3b_1 A B C_N VGND VNB VPB VPWR Y
.ends

* Black-box entry subcircuit for sky130_fd_sc_hd__ebufn_8 abstract view
.subckt sky130_fd_sc_hd__ebufn_8 A TE_B VGND VNB VPB VPWR Z
.ends

* Black-box entry subcircuit for sky130_fd_sc_hd__and4_2 abstract view
.subckt sky130_fd_sc_hd__and4_2 A B C D VGND VNB VPB VPWR X
.ends

* Black-box entry subcircuit for sky130_fd_sc_hd__and3b_1 abstract view
.subckt sky130_fd_sc_hd__and3b_1 A_N B C VGND VNB VPB VPWR X
.ends

* Black-box entry subcircuit for sky130_fd_sc_hd__or2_2 abstract view
.subckt sky130_fd_sc_hd__or2_2 A B VGND VNB VPB VPWR X
.ends

* Black-box entry subcircuit for sky130_fd_sc_hd__or3_2 abstract view
.subckt sky130_fd_sc_hd__or3_2 A B C VGND VNB VPB VPWR X
.ends

* Black-box entry subcircuit for sky130_fd_sc_hd__xnor2_1 abstract view
.subckt sky130_fd_sc_hd__xnor2_1 A B VGND VNB VPB VPWR Y
.ends

.subckt adc_top VGND VPWR busy channel_sel[0] channel_sel[1] channel_sel[2] clk cmp_out
+ conv_done cs_n dac_code[0] dac_code[1] dac_code[2] dac_code[3] dac_code[4] dac_code[5]
+ dac_code[6] dac_code[7] dac_code[8] dac_code[9] err_flag miso mosi result_channel[0]
+ result_channel[1] result_channel[2] result_data[0] result_data[1] result_data[2]
+ result_data[3] result_data[4] result_data[5] result_data[6] result_data[7] result_data[8]
+ result_data[9] result_valid rst_n sample_en sclk
XFILLER_26_85 VGND VGND VPWR VPWR sky130_fd_sc_hd__decap_4
X_432_ clknet_2_3__leaf_clk net85 net60 VGND VGND VPWR VPWR sar_result_w\[7\] sky130_fd_sc_hd__dfrtp_1
X_363_ net66 VGND VGND VPWR VPWR _043_ sky130_fd_sc_hd__inv_2
XFILLER_13_155 VPWR VGND VPWR VGND sky130_ef_sc_hd__decap_12
X_294_ u_spi.bit_count_q\[3\] _188_ VGND VGND VPWR VPWR _189_ sky130_fd_sc_hd__nand2_1
XFILLER_8_192 VGND VGND VPWR VPWR sky130_fd_sc_hd__decap_4
XFILLER_33_206 VPWR VGND VPWR VGND sky130_ef_sc_hd__decap_12
X_346_ net46 net61 VGND VGND VPWR VPWR _068_ sky130_fd_sc_hd__and2_1
X_415_ net50 _106_ net51 VGND VGND VPWR VPWR u_spi.req_channel_q\[0\] sky130_fd_sc_hd__dfrtp_1
XFILLER_6_107 VPWR VGND VPWR VGND sky130_ef_sc_hd__decap_12
XFILLER_6_129 VGND VGND VPWR VPWR sky130_fd_sc_hd__decap_8
X_277_ _153_ _163_ net17 VGND VGND VPWR VPWR _180_ sky130_fd_sc_hd__o21a_1
XFILLER_24_217 VGND VGND VPWR VPWR sky130_fd_sc_hd__decap_3
X_200_ net14 VGND VGND VPWR VPWR _132_ sky130_fd_sc_hd__inv_2
X_329_ net75 net7 net37 VGND VGND VPWR VPWR _120_ sky130_fd_sc_hd__mux2_1
XFILLER_9_11 VGND VGND VPWR VPWR sky130_fd_sc_hd__decap_3
XFILLER_9_33 VPWR VGND VPWR VGND sky130_ef_sc_hd__decap_12
XFILLER_9_66 VGND VGND VPWR VPWR sky130_fd_sc_hd__decap_8
XFILLER_34_41 VGND VGND VPWR VPWR sky130_fd_sc_hd__decap_4
XFILLER_18_97 VGND VGND VPWR VPWR sky130_fd_sc_hd__fill_1
XFILLER_18_75 VGND VGND VPWR VPWR sky130_fd_sc_hd__decap_8
Xhold41 sar_result_w\[5\] VGND VGND VPWR VPWR net107 sky130_fd_sc_hd__dlygate4sd3_1
XFILLER_28_172 VGND VGND VPWR VPWR sky130_fd_sc_hd__decap_3
Xhold30 sar_result_w\[8\] VGND VGND VPWR VPWR net96 sky130_fd_sc_hd__dlygate4sd3_1
XFILLER_20_65 VGND VGND VPWR VPWR sky130_fd_sc_hd__decap_4
XFILLER_34_197 VPWR VGND VPWR VGND sky130_ef_sc_hd__decap_12
XFILLER_19_150 VGND VGND VPWR VPWR sky130_fd_sc_hd__decap_6
XFILLER_13_3 VPWR VGND VPWR VGND sky130_ef_sc_hd__decap_12
XFILLER_15_43 VPWR VGND VPWR VGND sky130_ef_sc_hd__decap_12
Xoutput31 net31 VGND VGND VPWR VPWR result_data[6] sky130_fd_sc_hd__buf_2
XFILLER_31_178 VGND VGND VPWR VPWR sky130_fd_sc_hd__decap_4
XTAP_TAPCELL_ROW_26_170 VGND VPWR sky130_fd_sc_hd__tapvpwrvgnd_1
Xoutput20 net20 VGND VGND VPWR VPWR dac_code[9] sky130_fd_sc_hd__buf_2
XFILLER_16_197 VGND VGND VPWR VPWR sky130_fd_sc_hd__fill_1
XFILLER_16_153 VPWR VGND VPWR VGND sky130_ef_sc_hd__decap_12
Xoutput7 net7 VGND VGND VPWR VPWR channel_sel[0] sky130_fd_sc_hd__buf_2
X_431_ clknet_2_2__leaf_clk _115_ net58 VGND VGND VPWR VPWR sar_result_w\[6\] sky130_fd_sc_hd__dfrtp_1
XFILLER_26_75 VGND VGND VPWR VPWR sky130_fd_sc_hd__decap_3
XFILLER_13_167 VGND VGND VPWR VPWR sky130_fd_sc_hd__fill_1
X_293_ _187_ _188_ VGND VGND VPWR VPWR _029_ sky130_fd_sc_hd__nor2_1
XFILLER_3_35 VGND VGND VPWR VPWR sky130_fd_sc_hd__decap_3
X_362_ net45 net55 VGND VGND VPWR VPWR _041_ sky130_fd_sc_hd__and2_1
XFILLER_33_218 VGND VGND VPWR VPWR sky130_fd_sc_hd__fill_2
XFILLER_6_119 VGND VGND VPWR VPWR sky130_fd_sc_hd__fill_2
XFILLER_10_148 VGND VGND VPWR VPWR sky130_fd_sc_hd__decap_6
X_276_ _178_ _179_ net37 VGND VGND VPWR VPWR _005_ sky130_fd_sc_hd__o21a_1
X_345_ net46 net61 VGND VGND VPWR VPWR _070_ sky130_fd_sc_hd__and2_1
X_414_ clknet_2_1__leaf_clk net74 net51 VGND VGND VPWR VPWR conv_channel_w\[2\] sky130_fd_sc_hd__dfrtp_1
XFILLER_5_141 VGND VGND VPWR VPWR sky130_fd_sc_hd__decap_4
XPHY_EDGE_ROW_21_Right_21 VGND VGND VPWR VPWR sky130_fd_sc_hd__decap_3
XPHY_EDGE_ROW_12_Right_12 VGND VGND VPWR VPWR sky130_fd_sc_hd__decap_3
XPHY_EDGE_ROW_30_Right_30 VGND VGND VPWR VPWR sky130_fd_sc_hd__decap_3
X_259_ _133_ _136_ VGND VGND VPWR VPWR _166_ sky130_fd_sc_hd__nor2_1
X_328_ net87 net89 net40 VGND VGND VPWR VPWR _118_ sky130_fd_sc_hd__mux2_1
XFILLER_9_45 VGND VGND VPWR VPWR sky130_fd_sc_hd__decap_8
XFILLER_29_107 VGND VGND VPWR VPWR sky130_fd_sc_hd__decap_4
Xhold42 _114_ VGND VGND VPWR VPWR net108 sky130_fd_sc_hd__dlygate4sd3_1
XFILLER_29_86 VGND VGND VPWR VPWR sky130_fd_sc_hd__fill_1
XFILLER_29_42 VGND VGND VPWR VPWR sky130_fd_sc_hd__fill_2
XFILLER_29_31 VGND VGND VPWR VPWR sky130_fd_sc_hd__decap_4
Xhold20 net32 VGND VGND VPWR VPWR net86 sky130_fd_sc_hd__dlygate4sd3_1
Xhold31 _117_ VGND VGND VPWR VPWR net97 sky130_fd_sc_hd__dlygate4sd3_1
XFILLER_25_110 VGND VGND VPWR VPWR sky130_fd_sc_hd__fill_2
XFILLER_15_55 VGND VGND VPWR VPWR sky130_fd_sc_hd__fill_1
XPHY_EDGE_ROW_6_Right_6 VGND VGND VPWR VPWR sky130_fd_sc_hd__decap_3
Xoutput10 net42 VGND VGND VPWR VPWR conv_done sky130_fd_sc_hd__buf_2
XTAP_TAPCELL_ROW_26_171 VGND VPWR sky130_fd_sc_hd__tapvpwrvgnd_1
Xoutput32 net32 VGND VGND VPWR VPWR result_data[7] sky130_fd_sc_hd__buf_2
XFILLER_16_165 VPWR VGND VPWR VGND sky130_ef_sc_hd__decap_12
Xoutput21 net21 VGND VGND VPWR VPWR err_flag sky130_fd_sc_hd__buf_2
Xoutput8 net8 VGND VGND VPWR VPWR channel_sel[1] sky130_fd_sc_hd__buf_2
XFILLER_22_168 VGND VGND VPWR VPWR sky130_fd_sc_hd__fill_1
XFILLER_22_157 VGND VGND VPWR VPWR sky130_fd_sc_hd__fill_2
X_430_ clknet_2_3__leaf_clk net108 net58 VGND VGND VPWR VPWR sar_result_w\[5\] sky130_fd_sc_hd__dfrtp_1
XFILLER_26_54 VGND VGND VPWR VPWR sky130_fd_sc_hd__decap_3
X_292_ u_spi.bit_count_q\[0\] u_spi.bit_count_q\[1\] u_spi.bit_count_q\[2\] VGND VGND
+ VPWR VPWR _188_ sky130_fd_sc_hd__and3_1
XFILLER_13_113 VPWR VGND VPWR VGND sky130_ef_sc_hd__decap_12
X_361_ net47 net56 VGND VGND VPWR VPWR _040_ sky130_fd_sc_hd__and2_1
XFILLER_3_69 VGND VGND VPWR VPWR sky130_fd_sc_hd__fill_1
XTAP_TAPCELL_ROW_3_90 VGND VPWR sky130_fd_sc_hd__tapvpwrvgnd_1
X_275_ _157_ _161_ _176_ net16 VGND VGND VPWR VPWR _179_ sky130_fd_sc_hd__a2bb2o_1
X_344_ net46 net60 VGND VGND VPWR VPWR _072_ sky130_fd_sc_hd__and2_1
X_413_ clknet_2_1__leaf_clk net70 net51 VGND VGND VPWR VPWR conv_channel_w\[1\] sky130_fd_sc_hd__dfrtp_1
XFILLER_15_219 VGND VGND VPWR VPWR sky130_fd_sc_hd__fill_1
XFILLER_0_15 VPWR VGND VPWR VGND sky130_ef_sc_hd__decap_12
XFILLER_3_3 VPWR VGND VPWR VGND sky130_ef_sc_hd__decap_12
XFILLER_36_3 VPWR VGND VPWR VGND sky130_ef_sc_hd__decap_12
X_327_ net96 net19 net40 VGND VGND VPWR VPWR _117_ sky130_fd_sc_hd__mux2_1
X_258_ net37 _165_ VGND VGND VPWR VPWR _001_ sky130_fd_sc_hd__and2_1
XTAP_TAPCELL_ROW_0_80 VGND VPWR sky130_fd_sc_hd__tapvpwrvgnd_1
XFILLER_9_57 VGND VGND VPWR VPWR sky130_fd_sc_hd__decap_4
XPHY_EDGE_ROW_28_Left_65 VGND VGND VPWR VPWR sky130_fd_sc_hd__decap_3
XPHY_EDGE_ROW_12_Left_49 VGND VGND VPWR VPWR sky130_fd_sc_hd__decap_3
XFILLER_20_23 VGND VGND VPWR VPWR sky130_fd_sc_hd__decap_4
Xhold43 net30 VGND VGND VPWR VPWR net109 sky130_fd_sc_hd__dlygate4sd3_1
XFILLER_29_54 VGND VGND VPWR VPWR sky130_fd_sc_hd__fill_2
Xhold21 sar_result_w\[9\] VGND VGND VPWR VPWR net87 sky130_fd_sc_hd__dlygate4sd3_1
Xhold10 _120_ VGND VGND VPWR VPWR net76 sky130_fd_sc_hd__dlygate4sd3_1
Xhold32 net35 VGND VGND VPWR VPWR net98 sky130_fd_sc_hd__dlygate4sd3_1
XTAP_TAPCELL_ROW_29_180 VGND VPWR sky130_fd_sc_hd__tapvpwrvgnd_1
XFILLER_31_77 VGND VGND VPWR VPWR sky130_fd_sc_hd__decap_3
XFILLER_25_122 VGND VGND VPWR VPWR sky130_fd_sc_hd__decap_3
Xoutput33 net33 VGND VGND VPWR VPWR result_data[8] sky130_fd_sc_hd__buf_2
Xoutput11 net11 VGND VGND VPWR VPWR dac_code[0] sky130_fd_sc_hd__buf_2
Xoutput22 net22 VGND VGND VPWR VPWR result_channel[0] sky130_fd_sc_hd__buf_2
Xoutput9 net9 VGND VGND VPWR VPWR channel_sel[2] sky130_fd_sc_hd__buf_2
XFILLER_16_177 VPWR VGND VPWR VGND sky130_ef_sc_hd__decap_12
XFILLER_26_66 VGND VGND VPWR VPWR sky130_fd_sc_hd__decap_4
XFILLER_26_22 VGND VGND VPWR VPWR sky130_fd_sc_hd__decap_6
XPHY_EDGE_ROW_15_Left_52 VGND VGND VPWR VPWR sky130_fd_sc_hd__decap_3
X_360_ net45 net56 VGND VGND VPWR VPWR _039_ sky130_fd_sc_hd__and2_1
XFILLER_13_125 VGND VGND VPWR VPWR sky130_fd_sc_hd__decap_4
X_291_ u_spi.bit_count_q\[0\] u_spi.bit_count_q\[1\] u_spi.bit_count_q\[2\] VGND VGND
+ VPWR VPWR _187_ sky130_fd_sc_hd__a21oi_1
XFILLER_36_217 VGND VGND VPWR VPWR sky130_fd_sc_hd__decap_3
X_489_ clknet_2_2__leaf_clk _126_ net58 VGND VGND VPWR VPWR u_sar_core.state_q\[2\]
+ sky130_fd_sc_hd__dfrtp_1
XFILLER_3_15 VPWR VGND VPWR VGND sky130_ef_sc_hd__decap_12
XFILLER_27_217 VGND VGND VPWR VPWR sky130_fd_sc_hd__decap_3
XPHY_EDGE_ROW_0_Left_37 VGND VGND VPWR VPWR sky130_fd_sc_hd__decap_3
X_274_ _153_ _163_ VGND VGND VPWR VPWR _178_ sky130_fd_sc_hd__nor2_1
X_343_ net46 net60 VGND VGND VPWR VPWR _074_ sky130_fd_sc_hd__and2_1
XFILLER_18_206 VPWR VGND VPWR VGND sky130_ef_sc_hd__decap_12
X_412_ clknet_2_0__leaf_clk net72 net51 VGND VGND VPWR VPWR conv_channel_w\[0\] sky130_fd_sc_hd__dfrtp_1
XFILLER_23_89 VPWR VGND VPWR VGND sky130_ef_sc_hd__decap_12
XFILLER_23_34 VGND VGND VPWR VPWR sky130_fd_sc_hd__decap_8
XFILLER_2_146 VGND VGND VPWR VPWR sky130_fd_sc_hd__fill_1
XFILLER_0_27 VGND VGND VPWR VPWR sky130_fd_sc_hd__fill_1
X_326_ net84 net18 net40 VGND VGND VPWR VPWR _116_ sky130_fd_sc_hd__mux2_1
X_257_ _156_ _162_ _164_ VGND VGND VPWR VPWR _165_ sky130_fd_sc_hd__o21ai_1
XFILLER_1_190 VPWR VGND VPWR VGND sky130_ef_sc_hd__decap_12
X_309_ net24 net113 net41 VGND VGND VPWR VPWR _101_ sky130_fd_sc_hd__mux2_1
XPHY_EDGE_ROW_3_Left_40 VGND VGND VPWR VPWR sky130_fd_sc_hd__decap_3
XFILLER_7_205 VPWR VGND VPWR VGND sky130_ef_sc_hd__decap_12
XFILLER_1_92 VGND VGND VPWR VPWR sky130_fd_sc_hd__fill_2
XFILLER_4_208 VPWR VGND VPWR VGND sky130_ef_sc_hd__decap_12
XFILLER_28_197 VPWR VGND VPWR VGND sky130_ef_sc_hd__decap_12
XFILLER_28_164 VGND VGND VPWR VPWR sky130_fd_sc_hd__decap_8
Xhold22 _098_ VGND VGND VPWR VPWR net88 sky130_fd_sc_hd__dlygate4sd3_1
Xhold44 conv_start_w VGND VGND VPWR VPWR net110 sky130_fd_sc_hd__dlygate4sd3_1
Xhold33 conv_channel_w\[1\] VGND VGND VPWR VPWR net99 sky130_fd_sc_hd__dlygate4sd3_1
Xhold11 conv_channel_w\[2\] VGND VGND VPWR VPWR net77 sky130_fd_sc_hd__dlygate4sd3_1
XFILLER_6_15 VPWR VGND VPWR VGND sky130_ef_sc_hd__decap_12
XTAP_TAPCELL_ROW_29_181 VGND VPWR sky130_fd_sc_hd__tapvpwrvgnd_1
XFILLER_20_7 VGND VGND VPWR VPWR sky130_fd_sc_hd__decap_8
XFILLER_10_90 VGND VGND VPWR VPWR sky130_fd_sc_hd__decap_3
XFILLER_25_167 VGND VGND VPWR VPWR sky130_fd_sc_hd__fill_1
XFILLER_25_156 VGND VGND VPWR VPWR sky130_fd_sc_hd__fill_2
Xoutput12 net12 VGND VGND VPWR VPWR dac_code[1] sky130_fd_sc_hd__buf_2
Xoutput34 net34 VGND VGND VPWR VPWR result_data[9] sky130_fd_sc_hd__buf_2
XFILLER_15_57 VGND VGND VPWR VPWR sky130_fd_sc_hd__decap_6
Xoutput23 net23 VGND VGND VPWR VPWR result_channel[1] sky130_fd_sc_hd__buf_2
XFILLER_16_189 VGND VGND VPWR VPWR sky130_fd_sc_hd__decap_6
XFILLER_16_123 VGND VGND VPWR VPWR sky130_fd_sc_hd__decap_6
XFILLER_11_3 VGND VGND VPWR VPWR sky130_fd_sc_hd__decap_3
XFILLER_30_181 VGND VGND VPWR VPWR sky130_fd_sc_hd__fill_1
XFILLER_26_89 VGND VGND VPWR VPWR sky130_fd_sc_hd__fill_1
XFILLER_7_91 VGND VGND VPWR VPWR sky130_fd_sc_hd__fill_1
XFILLER_21_181 VPWR VGND VPWR VGND sky130_ef_sc_hd__decap_12
X_488_ clknet_2_2__leaf_clk _125_ net58 VGND VGND VPWR VPWR u_sar_core.state_q\[1\]
+ sky130_fd_sc_hd__dfrtp_4
X_290_ u_spi.bit_count_q\[0\] u_spi.bit_count_q\[1\] VGND VGND VPWR VPWR _028_ sky130_fd_sc_hd__xor2_1
XFILLER_3_27 VGND VGND VPWR VPWR sky130_fd_sc_hd__decap_8
XFILLER_8_141 VPWR VGND VPWR VGND sky130_ef_sc_hd__decap_12
X_273_ _176_ _177_ net37 VGND VGND VPWR VPWR _004_ sky130_fd_sc_hd__a21boi_1
XFILLER_18_218 VGND VGND VPWR VPWR sky130_fd_sc_hd__fill_2
X_342_ net45 net56 VGND VGND VPWR VPWR _076_ sky130_fd_sc_hd__and2_1
X_411_ net50 _102_ net52 VGND VGND VPWR VPWR u_spi.start_toggle_q sky130_fd_sc_hd__dfrtp_1
XFILLER_5_177 VGND VGND VPWR VPWR sky130_fd_sc_hd__fill_1
X_325_ net104 net106 _148_ VGND VGND VPWR VPWR _115_ sky130_fd_sc_hd__mux2_1
X_256_ _131_ _149_ _163_ _147_ VGND VGND VPWR VPWR _164_ sky130_fd_sc_hd__o22a_1
XFILLER_20_202 VPWR VGND VPWR VGND sky130_ef_sc_hd__decap_12
XFILLER_7_217 VGND VGND VPWR VPWR sky130_fd_sc_hd__decap_3
Xclkload0 clknet_2_0__leaf_clk VGND VGND VPWR VPWR clkload0/Y sky130_fd_sc_hd__clkinvlp_4
X_239_ _146_ _147_ VGND VGND VPWR VPWR _148_ sky130_fd_sc_hd__nor2_1
X_308_ net23 net111 net41 VGND VGND VPWR VPWR _100_ sky130_fd_sc_hd__mux2_1
Xhold23 net20 VGND VGND VPWR VPWR net89 sky130_fd_sc_hd__dlygate4sd3_1
Xhold34 _121_ VGND VGND VPWR VPWR net100 sky130_fd_sc_hd__dlygate4sd3_1
Xhold45 net8 VGND VGND VPWR VPWR net111 sky130_fd_sc_hd__dlygate4sd3_1
Xhold12 _122_ VGND VGND VPWR VPWR net78 sky130_fd_sc_hd__dlygate4sd3_1
XFILLER_19_165 VGND VGND VPWR VPWR sky130_fd_sc_hd__decap_3
XFILLER_6_27 VGND VGND VPWR VPWR sky130_fd_sc_hd__fill_1
Xoutput13 net13 VGND VGND VPWR VPWR dac_code[2] sky130_fd_sc_hd__buf_2
XFILLER_31_57 VPWR VGND VPWR VGND sky130_ef_sc_hd__decap_12
Xoutput35 net35 VGND VGND VPWR VPWR result_valid sky130_fd_sc_hd__buf_2
Xoutput24 net24 VGND VGND VPWR VPWR result_channel[2] sky130_fd_sc_hd__buf_2
XPHY_EDGE_ROW_28_Right_28 VGND VGND VPWR VPWR sky130_fd_sc_hd__decap_3
XPHY_EDGE_ROW_19_Right_19 VGND VGND VPWR VPWR sky130_fd_sc_hd__decap_3
XFILLER_16_102 VGND VGND VPWR VPWR sky130_fd_sc_hd__fill_1
XFILLER_22_149 VGND VGND VPWR VPWR sky130_fd_sc_hd__decap_8
XTAP_TAPCELL_ROW_9_109 VGND VPWR sky130_fd_sc_hd__tapvpwrvgnd_1
XFILLER_21_193 VPWR VGND VPWR VGND sky130_ef_sc_hd__decap_12
XFILLER_21_160 VGND VGND VPWR VPWR sky130_fd_sc_hd__decap_8
X_487_ clknet_2_1__leaf_clk _124_ net53 VGND VGND VPWR VPWR u_sar_core.state_q\[0\]
+ sky130_fd_sc_hd__dfrtp_1
XFILLER_8_153 VGND VGND VPWR VPWR sky130_fd_sc_hd__fill_2
XFILLER_8_197 VGND VGND VPWR VPWR sky130_fd_sc_hd__decap_4
X_272_ net15 _158_ _161_ _175_ VGND VGND VPWR VPWR _177_ sky130_fd_sc_hd__a22oi_1
XTAP_TAPCELL_ROW_20_147 VGND VPWR sky130_fd_sc_hd__tapvpwrvgnd_1
X_341_ net45 net56 VGND VGND VPWR VPWR _078_ sky130_fd_sc_hd__and2_1
X_410_ net50 u_spi.sgl_bit_w _036_ VGND VGND VPWR VPWR u_spi.start_bit_w sky130_fd_sc_hd__dfrtp_1
XFILLER_23_211 VGND VGND VPWR VPWR sky130_fd_sc_hd__decap_8
X_324_ net107 net16 net40 VGND VGND VPWR VPWR _114_ sky130_fd_sc_hd__mux2_1
X_255_ net44 _129_ VGND VGND VPWR VPWR _163_ sky130_fd_sc_hd__nand2_1
XFILLER_0_29 VPWR VGND VPWR VGND sky130_ef_sc_hd__decap_12
XFILLER_20_214 VGND VGND VPWR VPWR sky130_fd_sc_hd__fill_2
Xclkload1 clknet_2_2__leaf_clk VGND VGND VPWR VPWR clkload1/Y sky130_fd_sc_hd__bufinv_16
XFILLER_1_3 VPWR VGND VPWR VGND sky130_ef_sc_hd__decap_12
X_238_ net43 u_sar_core.state_q\[3\] VGND VGND VPWR VPWR _147_ sky130_fd_sc_hd__nand2b_2
X_307_ net22 net115 net41 VGND VGND VPWR VPWR _099_ sky130_fd_sc_hd__mux2_1
Xhold13 sar_result_w\[3\] VGND VGND VPWR VPWR net79 sky130_fd_sc_hd__dlygate4sd3_1
Xhold24 sar_result_w\[2\] VGND VGND VPWR VPWR net90 sky130_fd_sc_hd__dlygate4sd3_1
XFILLER_29_35 VGND VGND VPWR VPWR sky130_fd_sc_hd__fill_1
Xhold35 net26 VGND VGND VPWR VPWR net101 sky130_fd_sc_hd__dlygate4sd3_1
XFILLER_20_15 VGND VGND VPWR VPWR sky130_fd_sc_hd__decap_3
Xhold46 _100_ VGND VGND VPWR VPWR net112 sky130_fd_sc_hd__dlygate4sd3_1
XFILLER_19_90 VGND VGND VPWR VPWR sky130_fd_sc_hd__fill_2
XFILLER_10_81 VGND VGND VPWR VPWR sky130_fd_sc_hd__decap_3
XFILLER_15_15 VGND VGND VPWR VPWR sky130_fd_sc_hd__decap_8
Xoutput14 net14 VGND VGND VPWR VPWR dac_code[3] sky130_fd_sc_hd__buf_2
XFILLER_31_69 VGND VGND VPWR VPWR sky130_fd_sc_hd__decap_8
Xoutput36 net36 VGND VGND VPWR VPWR sample_en sky130_fd_sc_hd__buf_2
Xoutput25 net25 VGND VGND VPWR VPWR result_data[0] sky130_fd_sc_hd__buf_2
XTAP_TAPCELL_ROW_32_189 VGND VPWR sky130_fd_sc_hd__tapvpwrvgnd_1
XFILLER_22_139 VGND VGND VPWR VPWR sky130_fd_sc_hd__fill_1
XFILLER_22_128 VGND VGND VPWR VPWR sky130_fd_sc_hd__fill_2
XFILLER_15_191 VPWR VGND VPWR VGND sky130_ef_sc_hd__decap_12
XFILLER_36_209 VGND VGND VPWR VPWR sky130_fd_sc_hd__decap_8
XFILLER_27_209 VGND VGND VPWR VPWR sky130_fd_sc_hd__decap_8
XFILLER_12_150 VGND VGND VPWR VPWR sky130_fd_sc_hd__fill_1
X_486_ clknet_2_1__leaf_clk _123_ net54 VGND VGND VPWR VPWR net35 sky130_fd_sc_hd__dfrtp_1
XTAP_TAPCELL_ROW_20_148 VGND VPWR sky130_fd_sc_hd__tapvpwrvgnd_1
XPHY_EDGE_ROW_19_Left_56 VGND VGND VPWR VPWR sky130_fd_sc_hd__decap_3
XFILLER_12_27 VGND VGND VPWR VPWR sky130_fd_sc_hd__fill_1
XFILLER_27_90 VPWR VGND VPWR VGND sky130_ef_sc_hd__decap_12
X_271_ u_sar_core.state_q\[0\] _129_ _153_ VGND VGND VPWR VPWR _176_ sky130_fd_sc_hd__or3_1
XFILLER_5_113 VGND VGND VPWR VPWR sky130_fd_sc_hd__decap_4
X_340_ net45 net55 VGND VGND VPWR VPWR _080_ sky130_fd_sc_hd__and2_1
XFILLER_4_190 VGND VGND VPWR VPWR sky130_fd_sc_hd__decap_6
X_469_ _083_ _015_ _082_ VGND VGND VPWR VPWR u_spi.tx_shift_q\[13\] sky130_fd_sc_hd__dfrtp_1
X_323_ net92 net95 net40 VGND VGND VPWR VPWR _113_ sky130_fd_sc_hd__mux2_1
Xfanout60 net63 VGND VGND VPWR VPWR net60 sky130_fd_sc_hd__buf_2
X_254_ net44 _129_ u_sar_core.state_q\[2\] _130_ VGND VGND VPWR VPWR _162_ sky130_fd_sc_hd__or4_1
XFILLER_2_138 VGND VGND VPWR VPWR sky130_fd_sc_hd__fill_2
XFILLER_1_160 VGND VGND VPWR VPWR sky130_fd_sc_hd__decap_8
XFILLER_18_26 VGND VGND VPWR VPWR sky130_fd_sc_hd__fill_2
XFILLER_11_204 VPWR VGND VPWR VGND sky130_ef_sc_hd__decap_12
XFILLER_27_3 VPWR VGND VPWR VGND sky130_ef_sc_hd__decap_12
X_237_ net44 u_sar_core.state_q\[1\] VGND VGND VPWR VPWR _146_ sky130_fd_sc_hd__nand2_2
X_306_ net34 net87 net41 VGND VGND VPWR VPWR _098_ sky130_fd_sc_hd__mux2_1
Xhold14 _092_ VGND VGND VPWR VPWR net80 sky130_fd_sc_hd__dlygate4sd3_1
Xhold25 _111_ VGND VGND VPWR VPWR net91 sky130_fd_sc_hd__dlygate4sd3_1
Xhold36 net27 VGND VGND VPWR VPWR net102 sky130_fd_sc_hd__dlygate4sd3_1
XFILLER_20_27 VGND VGND VPWR VPWR sky130_fd_sc_hd__fill_1
XFILLER_1_51 VGND VGND VPWR VPWR sky130_fd_sc_hd__decap_4
Xhold47 net9 VGND VGND VPWR VPWR net113 sky130_fd_sc_hd__dlygate4sd3_1
XPHY_EDGE_ROW_7_Left_44 VGND VGND VPWR VPWR sky130_fd_sc_hd__decap_3
Xoutput15 net15 VGND VGND VPWR VPWR dac_code[4] sky130_fd_sc_hd__buf_2
XFILLER_31_48 VGND VGND VPWR VPWR sky130_fd_sc_hd__decap_8
XFILLER_31_15 VPWR VGND VPWR VGND sky130_ef_sc_hd__decap_12
Xoutput26 net26 VGND VGND VPWR VPWR result_data[1] sky130_fd_sc_hd__buf_2
XPHY_EDGE_ROW_1_Right_1 VGND VGND VPWR VPWR sky130_fd_sc_hd__decap_3
XFILLER_26_15 VGND VGND VPWR VPWR sky130_fd_sc_hd__decap_4
XFILLER_13_129 VGND VGND VPWR VPWR sky130_fd_sc_hd__fill_1
X_485_ clknet_2_0__leaf_clk _009_ net58 VGND VGND VPWR VPWR net20 sky130_fd_sc_hd__dfrtp_1
XFILLER_12_195 VGND VGND VPWR VPWR sky130_fd_sc_hd__fill_1
XTAP_TAPCELL_ROW_20_149 VGND VPWR sky130_fd_sc_hd__tapvpwrvgnd_1
XPHY_EDGE_ROW_36_Left_73 VGND VGND VPWR VPWR sky130_fd_sc_hd__decap_3
X_270_ net1 _155_ _167_ _168_ VGND VGND VPWR VPWR _175_ sky130_fd_sc_hd__and4_1
XPHY_EDGE_ROW_20_Left_57 VGND VGND VPWR VPWR sky130_fd_sc_hd__decap_3
XFILLER_17_210 VGND VGND VPWR VPWR sky130_fd_sc_hd__decap_6
XFILLER_5_169 VGND VGND VPWR VPWR sky130_fd_sc_hd__decap_8
XTAP_TAPCELL_ROW_11_116 VGND VPWR sky130_fd_sc_hd__tapvpwrvgnd_1
X_399_ clknet_2_2__leaf_clk net105 net58 VGND VGND VPWR VPWR net31 sky130_fd_sc_hd__dfrtp_1
X_468_ _081_ _014_ _080_ VGND VGND VPWR VPWR u_spi.tx_shift_q\[12\] sky130_fd_sc_hd__dfrtp_1
X_322_ net79 net83 net40 VGND VGND VPWR VPWR _112_ sky130_fd_sc_hd__mux2_1
XFILLER_23_27 VGND VGND VPWR VPWR sky130_fd_sc_hd__fill_1
Xfanout61 net63 VGND VGND VPWR VPWR net61 sky130_fd_sc_hd__clkbuf_4
XFILLER_29_7 VPWR VGND VPWR VGND sky130_ef_sc_hd__decap_12
X_253_ _158_ _159_ VGND VGND VPWR VPWR _161_ sky130_fd_sc_hd__nand2_1
Xfanout50 net5 VGND VGND VPWR VPWR net50 sky130_fd_sc_hd__buf_2
XTAP_TAPCELL_ROW_0_74 VGND VPWR sky130_fd_sc_hd__tapvpwrvgnd_1
XFILLER_34_26 VGND VGND VPWR VPWR sky130_fd_sc_hd__fill_2
X_236_ net44 u_sar_core.state_q\[1\] VGND VGND VPWR VPWR _145_ sky130_fd_sc_hd__and2_1
X_305_ net103 net96 net42 VGND VGND VPWR VPWR _097_ sky130_fd_sc_hd__mux2_1
XPHY_EDGE_ROW_23_Left_60 VGND VGND VPWR VPWR sky130_fd_sc_hd__decap_3
Xhold26 sar_result_w\[4\] VGND VGND VPWR VPWR net92 sky130_fd_sc_hd__dlygate4sd3_1
XFILLER_28_157 VGND VGND VPWR VPWR sky130_fd_sc_hd__fill_2
Xhold37 net33 VGND VGND VPWR VPWR net103 sky130_fd_sc_hd__dlygate4sd3_1
XFILLER_19_113 VGND VGND VPWR VPWR sky130_fd_sc_hd__decap_6
Xhold15 sar_result_w\[0\] VGND VGND VPWR VPWR net81 sky130_fd_sc_hd__dlygate4sd3_1
Xhold48 _101_ VGND VGND VPWR VPWR net114 sky130_fd_sc_hd__dlygate4sd3_1
XFILLER_10_61 VPWR VGND VPWR VGND sky130_ef_sc_hd__decap_12
X_219_ u_spi.tx_shift_q\[1\] u_spi.tx_snapshot_q\[1\] net38 VGND VGND VPWR VPWR _019_
+ sky130_fd_sc_hd__mux2_1
Xoutput27 net27 VGND VGND VPWR VPWR result_data[2] sky130_fd_sc_hd__buf_2
Xoutput16 net16 VGND VGND VPWR VPWR dac_code[5] sky130_fd_sc_hd__buf_2
XFILLER_31_27 VPWR VGND VPWR VGND sky130_ef_sc_hd__decap_12
XFILLER_16_138 VGND VGND VPWR VPWR sky130_fd_sc_hd__fill_2
XFILLER_30_130 VGND VGND VPWR VPWR sky130_fd_sc_hd__decap_6
Xclkbuf_0_clk clk VGND VGND VPWR VPWR clknet_0_clk sky130_fd_sc_hd__clkbuf_16
XPHY_EDGE_ROW_24_Right_24 VGND VGND VPWR VPWR sky130_fd_sc_hd__decap_3
XTAP_TAPCELL_ROW_23_158 VGND VPWR sky130_fd_sc_hd__tapvpwrvgnd_1
XPHY_EDGE_ROW_15_Right_15 VGND VGND VPWR VPWR sky130_fd_sc_hd__decap_3
XFILLER_13_108 VGND VGND VPWR VPWR sky130_fd_sc_hd__decap_4
XFILLER_7_62 VGND VGND VPWR VPWR sky130_fd_sc_hd__decap_3
XPHY_EDGE_ROW_33_Right_33 VGND VGND VPWR VPWR sky130_fd_sc_hd__decap_3
X_484_ clknet_2_2__leaf_clk _008_ net58 VGND VGND VPWR VPWR net19 sky130_fd_sc_hd__dfrtp_1
XFILLER_12_174 VPWR VGND VPWR VGND sky130_ef_sc_hd__decap_12
XFILLER_12_141 VGND VGND VPWR VPWR sky130_fd_sc_hd__fill_1
XFILLER_8_112 VGND VGND VPWR VPWR sky130_fd_sc_hd__fill_2
XFILLER_12_29 VPWR VGND VPWR VGND sky130_ef_sc_hd__decap_12
XTAP_TAPCELL_ROW_11_117 VGND VPWR sky130_fd_sc_hd__tapvpwrvgnd_1
XFILLER_5_137 VGND VGND VPWR VPWR sky130_fd_sc_hd__fill_1
X_398_ clknet_2_3__leaf_clk _094_ net61 VGND VGND VPWR VPWR net30 sky130_fd_sc_hd__dfrtp_1
X_467_ _079_ _013_ _078_ VGND VGND VPWR VPWR u_spi.tx_shift_q\[11\] sky130_fd_sc_hd__dfrtp_1
XFILLER_4_85 VGND VGND VPWR VPWR sky130_fd_sc_hd__decap_4
Xfanout62 net63 VGND VGND VPWR VPWR net62 sky130_fd_sc_hd__dlymetal6s2s_1
X_321_ net90 net13 net40 VGND VGND VPWR VPWR _111_ sky130_fd_sc_hd__mux2_1
X_252_ _158_ _159_ VGND VGND VPWR VPWR _160_ sky130_fd_sc_hd__and2_1
Xfanout40 _148_ VGND VGND VPWR VPWR net40 sky130_fd_sc_hd__clkbuf_4
XFILLER_1_140 VGND VGND VPWR VPWR sky130_fd_sc_hd__decap_4
XTAP_TAPCELL_ROW_0_75 VGND VPWR sky130_fd_sc_hd__tapvpwrvgnd_1
Xfanout51 net53 VGND VGND VPWR VPWR net51 sky130_fd_sc_hd__buf_2
X_304_ net86 net84 net42 VGND VGND VPWR VPWR _096_ sky130_fd_sc_hd__mux2_1
XFILLER_24_82 VGND VGND VPWR VPWR sky130_fd_sc_hd__fill_2
X_235_ conv_start_w _137_ VGND VGND VPWR VPWR _144_ sky130_fd_sc_hd__nand2_1
XFILLER_6_210 VGND VGND VPWR VPWR sky130_fd_sc_hd__decap_8
XFILLER_34_6 VPWR VGND VPWR VGND sky130_ef_sc_hd__decap_12
XFILLER_20_29 VPWR VGND VPWR VGND sky130_ef_sc_hd__decap_12
Xhold27 _093_ VGND VGND VPWR VPWR net93 sky130_fd_sc_hd__dlygate4sd3_1
Xhold38 sar_result_w\[6\] VGND VGND VPWR VPWR net104 sky130_fd_sc_hd__dlygate4sd3_1
XFILLER_28_103 VGND VGND VPWR VPWR sky130_fd_sc_hd__decap_4
Xhold16 net25 VGND VGND VPWR VPWR net82 sky130_fd_sc_hd__dlygate4sd3_1
XFILLER_3_202 VPWR VGND VPWR VGND sky130_ef_sc_hd__decap_12
Xhold49 net7 VGND VGND VPWR VPWR net115 sky130_fd_sc_hd__dlygate4sd3_1
XFILLER_10_73 VGND VGND VPWR VPWR sky130_fd_sc_hd__decap_8
XFILLER_34_139 VGND VGND VPWR VPWR sky130_fd_sc_hd__fill_1
XFILLER_32_3 VPWR VGND VPWR VGND sky130_ef_sc_hd__decap_12
XFILLER_19_169 VPWR VGND VPWR VGND sky130_ef_sc_hd__decap_12
X_218_ u_spi.tx_snapshot_q\[0\] net38 VGND VGND VPWR VPWR _018_ sky130_fd_sc_hd__and2_1
Xoutput28 net28 VGND VGND VPWR VPWR result_data[3] sky130_fd_sc_hd__buf_2
Xoutput17 net17 VGND VGND VPWR VPWR dac_code[6] sky130_fd_sc_hd__buf_2
XFILLER_33_194 VPWR VGND VPWR VGND sky130_ef_sc_hd__decap_12
XFILLER_31_39 VGND VGND VPWR VPWR sky130_fd_sc_hd__fill_1
XFILLER_21_50 VGND VGND VPWR VPWR sky130_fd_sc_hd__decap_6
XFILLER_7_85 VGND VGND VPWR VPWR sky130_fd_sc_hd__decap_6
X_483_ clknet_2_2__leaf_clk _007_ net58 VGND VGND VPWR VPWR net18 sky130_fd_sc_hd__dfrtp_1
XTAP_TAPCELL_ROW_23_159 VGND VPWR sky130_fd_sc_hd__tapvpwrvgnd_1
XFILLER_16_83 VGND VGND VPWR VPWR sky130_fd_sc_hd__fill_1
XTAP_TAPCELL_ROW_14_126 VGND VPWR sky130_fd_sc_hd__tapvpwrvgnd_1
XFILLER_12_186 VGND VGND VPWR VPWR sky130_fd_sc_hd__decap_6
XFILLER_12_19 VGND VGND VPWR VPWR sky130_fd_sc_hd__decap_8
XTAP_TAPCELL_ROW_11_118 VGND VPWR sky130_fd_sc_hd__tapvpwrvgnd_1
X_397_ clknet_2_3__leaf_clk net93 net61 VGND VGND VPWR VPWR net29 sky130_fd_sc_hd__dfrtp_1
X_466_ _077_ _012_ _076_ VGND VGND VPWR VPWR u_spi.tx_shift_q\[10\] sky130_fd_sc_hd__dfrtp_1
Xclkbuf_2_0__f_clk clknet_0_clk VGND VGND VPWR VPWR clknet_2_0__leaf_clk sky130_fd_sc_hd__clkbuf_16
XFILLER_2_119 VGND VGND VPWR VPWR sky130_fd_sc_hd__fill_2
Xfanout63 net64 VGND VGND VPWR VPWR net63 sky130_fd_sc_hd__clkbuf_2
X_251_ net43 _134_ _145_ VGND VGND VPWR VPWR _159_ sky130_fd_sc_hd__or3_1
X_320_ net94 net12 net40 VGND VGND VPWR VPWR _110_ sky130_fd_sc_hd__mux2_1
Xfanout52 net53 VGND VGND VPWR VPWR net52 sky130_fd_sc_hd__clkbuf_4
XFILLER_14_215 VGND VGND VPWR VPWR sky130_fd_sc_hd__fill_1
Xfanout41 net10 VGND VGND VPWR VPWR net41 sky130_fd_sc_hd__clkbuf_4
XFILLER_13_84 VPWR VGND VPWR VGND sky130_ef_sc_hd__decap_12
XTAP_TAPCELL_ROW_0_76 VGND VPWR sky130_fd_sc_hd__tapvpwrvgnd_1
X_449_ _050_ net33 net63 VGND VGND VPWR VPWR u_spi.tx_snapshot_q\[8\] sky130_fd_sc_hd__dfrtp_1
X_303_ net31 net104 net42 VGND VGND VPWR VPWR _095_ sky130_fd_sc_hd__mux2_1
XFILLER_1_98 VGND VGND VPWR VPWR sky130_fd_sc_hd__fill_1
X_234_ u_spi.tx_shift_q\[15\] u_spi.tx_snapshot_q\[15\] _143_ VGND VGND VPWR VPWR
+ u_spi.miso_bit sky130_fd_sc_hd__mux2_1
XFILLER_6_200 VGND VGND VPWR VPWR sky130_fd_sc_hd__fill_1
XFILLER_36_181 VPWR VGND VPWR VGND sky130_ef_sc_hd__decap_12
Xhold39 _095_ VGND VGND VPWR VPWR net105 sky130_fd_sc_hd__dlygate4sd3_1
Xhold17 net14 VGND VGND VPWR VPWR net83 sky130_fd_sc_hd__dlygate4sd3_1
Xhold28 sar_result_w\[1\] VGND VGND VPWR VPWR net94 sky130_fd_sc_hd__dlygate4sd3_1
XFILLER_27_181 VGND VGND VPWR VPWR sky130_fd_sc_hd__decap_4
X_217_ u_spi.bit_count_q\[3\] u_spi.bit_count_q\[2\] _138_ VGND VGND VPWR VPWR _142_
+ sky130_fd_sc_hd__nor3_1
XFILLER_3_214 VGND VGND VPWR VPWR sky130_fd_sc_hd__decap_6
Xoutput29 net29 VGND VGND VPWR VPWR result_data[4] sky130_fd_sc_hd__buf_2
Xoutput18 net18 VGND VGND VPWR VPWR dac_code[7] sky130_fd_sc_hd__buf_2
XFILLER_33_173 VGND VGND VPWR VPWR sky130_fd_sc_hd__fill_1
XFILLER_25_3 VGND VGND VPWR VPWR sky130_fd_sc_hd__decap_8
XFILLER_0_217 VGND VGND VPWR VPWR sky130_fd_sc_hd__decap_3
XTAP_TAPCELL_ROW_26_168 VGND VPWR sky130_fd_sc_hd__tapvpwrvgnd_1
XFILLER_24_195 VGND VGND VPWR VPWR sky130_fd_sc_hd__fill_1
XFILLER_21_84 VPWR VGND VPWR VGND sky130_ef_sc_hd__decap_12
XFILLER_21_73 VGND VGND VPWR VPWR sky130_fd_sc_hd__fill_1
XFILLER_30_121 VGND VGND VPWR VPWR sky130_fd_sc_hd__fill_1
XFILLER_26_29 VGND VGND VPWR VPWR sky130_fd_sc_hd__fill_2
XPHY_EDGE_ROW_5_Right_5 VGND VGND VPWR VPWR sky130_fd_sc_hd__decap_3
XFILLER_32_83 VGND VGND VPWR VPWR sky130_fd_sc_hd__fill_1
X_482_ clknet_2_2__leaf_clk _006_ net59 VGND VGND VPWR VPWR net17 sky130_fd_sc_hd__dfrtp_1
XFILLER_16_51 VGND VGND VPWR VPWR sky130_fd_sc_hd__fill_1
XTAP_TAPCELL_ROW_14_127 VGND VPWR sky130_fd_sc_hd__tapvpwrvgnd_1
XFILLER_8_103 VGND VGND VPWR VPWR sky130_fd_sc_hd__fill_1
XFILLER_26_202 VPWR VGND VPWR VGND sky130_ef_sc_hd__decap_12
X_396_ clknet_2_3__leaf_clk net80 net61 VGND VGND VPWR VPWR net28 sky130_fd_sc_hd__dfrtp_1
X_465_ _075_ _026_ _074_ VGND VGND VPWR VPWR u_spi.tx_shift_q\[9\] sky130_fd_sc_hd__dfrtp_1
XFILLER_23_19 VGND VGND VPWR VPWR sky130_fd_sc_hd__decap_8
Xfanout64 net4 VGND VGND VPWR VPWR net64 sky130_fd_sc_hd__clkbuf_2
X_250_ _146_ _153_ VGND VGND VPWR VPWR _158_ sky130_fd_sc_hd__or2_1
Xfanout42 net10 VGND VGND VPWR VPWR net42 sky130_fd_sc_hd__clkbuf_2
Xfanout53 net64 VGND VGND VPWR VPWR net53 sky130_fd_sc_hd__buf_2
XFILLER_13_96 VPWR VGND VPWR VGND sky130_ef_sc_hd__decap_12
X_448_ _049_ net32 net63 VGND VGND VPWR VPWR u_spi.tx_snapshot_q\[7\] sky130_fd_sc_hd__dfrtp_1
X_379_ net49 VGND VGND VPWR VPWR _063_ sky130_fd_sc_hd__inv_2
XTAP_TAPCELL_ROW_0_77 VGND VPWR sky130_fd_sc_hd__tapvpwrvgnd_1
XFILLER_34_29 VPWR VGND VPWR VGND sky130_ef_sc_hd__decap_12
XFILLER_34_18 VGND VGND VPWR VPWR sky130_fd_sc_hd__decap_8
X_302_ net109 net107 net42 VGND VGND VPWR VPWR _094_ sky130_fd_sc_hd__mux2_1
XFILLER_1_66 VGND VGND VPWR VPWR sky130_fd_sc_hd__decap_6
XFILLER_1_55 VGND VGND VPWR VPWR sky130_fd_sc_hd__fill_1
X_233_ u_spi.bit_count_q\[4\] _010_ VGND VGND VPWR VPWR _143_ sky130_fd_sc_hd__nor2_1
XFILLER_36_193 VGND VGND VPWR VPWR sky130_fd_sc_hd__decap_3
Xhold29 net15 VGND VGND VPWR VPWR net95 sky130_fd_sc_hd__dlygate4sd3_1
XFILLER_28_149 VGND VGND VPWR VPWR sky130_fd_sc_hd__decap_8
Xhold18 sar_result_w\[7\] VGND VGND VPWR VPWR net84 sky130_fd_sc_hd__dlygate4sd3_1
XFILLER_35_61 VGND VGND VPWR VPWR sky130_fd_sc_hd__fill_1
XFILLER_19_138 VPWR VGND VPWR VGND sky130_ef_sc_hd__decap_12
XTAP_TAPCELL_ROW_6_98 VGND VPWR sky130_fd_sc_hd__tapvpwrvgnd_1
XPHY_EDGE_ROW_27_Left_64 VGND VGND VPWR VPWR sky130_fd_sc_hd__decap_3
XFILLER_18_193 VGND VGND VPWR VPWR sky130_fd_sc_hd__decap_3
XFILLER_18_3 VGND VGND VPWR VPWR sky130_fd_sc_hd__decap_3
X_216_ u_spi.bit_count_q\[0\] u_spi.bit_count_q\[1\] u_spi.bit_count_q\[3\] u_spi.bit_count_q\[2\]
+ VGND VGND VPWR VPWR _010_ sky130_fd_sc_hd__or4_1
XPHY_EDGE_ROW_11_Left_48 VGND VGND VPWR VPWR sky130_fd_sc_hd__decap_3
XTAP_TAPCELL_ROW_26_169 VGND VPWR sky130_fd_sc_hd__tapvpwrvgnd_1
XFILLER_24_141 VPWR VGND VPWR VGND sky130_ef_sc_hd__decap_12
Xoutput19 net19 VGND VGND VPWR VPWR dac_code[8] sky130_fd_sc_hd__buf_2
XFILLER_21_96 VGND VGND VPWR VPWR sky130_fd_sc_hd__decap_6
XFILLER_15_141 VPWR VGND VPWR VGND sky130_ef_sc_hd__decap_12
X_481_ clknet_2_2__leaf_clk _005_ net59 VGND VGND VPWR VPWR net16 sky130_fd_sc_hd__dfrtp_1
XPHY_EDGE_ROW_20_Right_20 VGND VGND VPWR VPWR sky130_fd_sc_hd__decap_3
XTAP_TAPCELL_ROW_14_128 VGND VPWR sky130_fd_sc_hd__tapvpwrvgnd_1
XPHY_EDGE_ROW_11_Right_11 VGND VGND VPWR VPWR sky130_fd_sc_hd__decap_3
XTAP_TAPCELL_ROW_3_88 VGND VPWR sky130_fd_sc_hd__tapvpwrvgnd_1
XFILLER_26_214 VGND VGND VPWR VPWR sky130_fd_sc_hd__decap_6
XFILLER_7_181 VPWR VGND VPWR VGND sky130_ef_sc_hd__decap_12
XFILLER_32_217 VGND VGND VPWR VPWR sky130_fd_sc_hd__decap_3
X_464_ _073_ _025_ _072_ VGND VGND VPWR VPWR u_spi.tx_shift_q\[8\] sky130_fd_sc_hd__dfrtp_1
XPHY_EDGE_ROW_14_Left_51 VGND VGND VPWR VPWR sky130_fd_sc_hd__decap_3
X_395_ clknet_2_3__leaf_clk _091_ net61 VGND VGND VPWR VPWR net27 sky130_fd_sc_hd__dfrtp_1
XFILLER_4_162 VGND VGND VPWR VPWR sky130_fd_sc_hd__decap_4
Xfanout43 u_sar_core.state_q\[2\] VGND VGND VPWR VPWR net43 sky130_fd_sc_hd__buf_2
Xfanout65 net2 VGND VGND VPWR VPWR net65 sky130_fd_sc_hd__buf_4
Xfanout54 net57 VGND VGND VPWR VPWR net54 sky130_fd_sc_hd__buf_2
X_447_ _048_ net31 net62 VGND VGND VPWR VPWR u_spi.tx_snapshot_q\[6\] sky130_fd_sc_hd__dfrtp_1
X_378_ net49 VGND VGND VPWR VPWR _061_ sky130_fd_sc_hd__inv_2
XTAP_TAPCELL_ROW_0_78 VGND VPWR sky130_fd_sc_hd__tapvpwrvgnd_1
X_301_ net29 net92 net41 VGND VGND VPWR VPWR _093_ sky130_fd_sc_hd__mux2_1
XFILLER_24_41 VPWR VGND VPWR VGND sky130_ef_sc_hd__decap_12
X_232_ u_spi.tx_shift_q\[14\] u_spi.tx_snapshot_q\[14\] net38 VGND VGND VPWR VPWR
+ _017_ sky130_fd_sc_hd__mux2_1
XFILLER_29_19 VPWR VGND VPWR VGND sky130_ef_sc_hd__decap_12
XFILLER_28_117 VGND VGND VPWR VPWR sky130_fd_sc_hd__decap_3
Xhold19 _116_ VGND VGND VPWR VPWR net85 sky130_fd_sc_hd__dlygate4sd3_1
XFILLER_36_161 VGND VGND VPWR VPWR sky130_fd_sc_hd__decap_3
XFILLER_19_128 VGND VGND VPWR VPWR sky130_fd_sc_hd__fill_2
X_215_ _136_ _141_ VGND VGND VPWR VPWR net10 sky130_fd_sc_hd__nor2_1
XTAP_TAPCELL_ROW_6_99 VGND VPWR sky130_fd_sc_hd__tapvpwrvgnd_1
XFILLER_24_197 VGND VGND VPWR VPWR sky130_fd_sc_hd__decap_3
XFILLER_24_153 VPWR VGND VPWR VGND sky130_ef_sc_hd__decap_12
XTAP_TAPCELL_ROW_17_137 VGND VPWR sky130_fd_sc_hd__tapvpwrvgnd_1
XFILLER_15_153 VPWR VGND VPWR VGND sky130_ef_sc_hd__decap_12
XFILLER_7_55 VGND VGND VPWR VPWR sky130_fd_sc_hd__fill_1
XFILLER_30_3 VPWR VGND VPWR VGND sky130_ef_sc_hd__decap_12
XTAP_TAPCELL_ROW_8_105 VGND VPWR sky130_fd_sc_hd__tapvpwrvgnd_1
XFILLER_32_85 VPWR VGND VPWR VGND sky130_ef_sc_hd__decap_12
XFILLER_32_41 VPWR VGND VPWR VGND sky130_ef_sc_hd__decap_12
X_480_ clknet_2_3__leaf_clk _004_ net59 VGND VGND VPWR VPWR net15 sky130_fd_sc_hd__dfrtp_1
XFILLER_16_75 VGND VGND VPWR VPWR sky130_fd_sc_hd__decap_8
XTAP_TAPCELL_ROW_14_129 VGND VPWR sky130_fd_sc_hd__tapvpwrvgnd_1
XFILLER_12_134 VGND VGND VPWR VPWR sky130_fd_sc_hd__decap_3
XTAP_TAPCELL_ROW_3_89 VGND VPWR sky130_fd_sc_hd__tapvpwrvgnd_1
XFILLER_8_138 VGND VGND VPWR VPWR sky130_fd_sc_hd__fill_2
XFILLER_7_193 VPWR VGND VPWR VGND sky130_ef_sc_hd__decap_12
XFILLER_5_108 VGND VGND VPWR VPWR sky130_fd_sc_hd__decap_4
X_463_ _071_ _024_ _070_ VGND VGND VPWR VPWR u_spi.tx_shift_q\[7\] sky130_fd_sc_hd__dfrtp_1
X_394_ clknet_2_3__leaf_clk _090_ net60 VGND VGND VPWR VPWR net26 sky130_fd_sc_hd__dfrtp_1
XFILLER_4_78 VGND VGND VPWR VPWR sky130_fd_sc_hd__decap_6
XFILLER_4_89 VGND VGND VPWR VPWR sky130_fd_sc_hd__fill_1
XFILLER_4_130 VGND VGND VPWR VPWR sky130_fd_sc_hd__decap_8
XFILLER_4_141 VPWR VGND VPWR VGND sky130_ef_sc_hd__decap_12
Xfanout44 u_sar_core.state_q\[0\] VGND VGND VPWR VPWR net44 sky130_fd_sc_hd__buf_2
Xfanout55 net57 VGND VGND VPWR VPWR net55 sky130_fd_sc_hd__clkbuf_2
Xfanout66 net2 VGND VGND VPWR VPWR net66 sky130_fd_sc_hd__clkbuf_4
X_446_ _047_ net30 net62 VGND VGND VPWR VPWR u_spi.tx_snapshot_q\[5\] sky130_fd_sc_hd__dfrtp_1
XTAP_TAPCELL_ROW_0_79 VGND VPWR sky130_fd_sc_hd__tapvpwrvgnd_1
XFILLER_1_155 VGND VGND VPWR VPWR sky130_fd_sc_hd__fill_2
X_377_ net65 VGND VGND VPWR VPWR _057_ sky130_fd_sc_hd__inv_2
XFILLER_8_3 VPWR VGND VPWR VGND sky130_ef_sc_hd__decap_12
X_300_ net28 net79 net41 VGND VGND VPWR VPWR _092_ sky130_fd_sc_hd__mux2_1
X_231_ u_spi.tx_shift_q\[13\] u_spi.tx_snapshot_q\[13\] net38 VGND VGND VPWR VPWR
+ _016_ sky130_fd_sc_hd__mux2_1
X_429_ clknet_2_3__leaf_clk _113_ net61 VGND VGND VPWR VPWR sar_result_w\[4\] sky130_fd_sc_hd__dfrtp_1
XFILLER_28_107 VGND VGND VPWR VPWR sky130_fd_sc_hd__fill_1
Xinput1 cmp_out VGND VGND VPWR VPWR net1 sky130_fd_sc_hd__dlymetal6s2s_1
XFILLER_19_64 VGND VGND VPWR VPWR sky130_fd_sc_hd__fill_2
XTAP_TAPCELL_ROW_29_179 VGND VPWR sky130_fd_sc_hd__tapvpwrvgnd_1
X_214_ net43 u_sar_core.state_q\[3\] VGND VGND VPWR VPWR _141_ sky130_fd_sc_hd__nand2_2
XFILLER_33_165 VGND VGND VPWR VPWR sky130_fd_sc_hd__decap_3
XFILLER_33_154 VGND VGND VPWR VPWR sky130_fd_sc_hd__decap_8
XFILLER_33_121 VGND VGND VPWR VPWR sky130_fd_sc_hd__decap_6
XFILLER_0_209 VGND VGND VPWR VPWR sky130_fd_sc_hd__decap_8
XFILLER_24_165 VPWR VGND VPWR VGND sky130_ef_sc_hd__decap_12
XTAP_TAPCELL_ROW_17_138 VGND VPWR sky130_fd_sc_hd__tapvpwrvgnd_1
XFILLER_15_165 VGND VGND VPWR VPWR sky130_fd_sc_hd__decap_3
XFILLER_21_113 VPWR VGND VPWR VGND sky130_ef_sc_hd__decap_12
XFILLER_21_102 VGND VGND VPWR VPWR sky130_fd_sc_hd__fill_1
XFILLER_7_23 VGND VGND VPWR VPWR sky130_fd_sc_hd__fill_2
XFILLER_7_34 VGND VGND VPWR VPWR sky130_fd_sc_hd__fill_1
XFILLER_32_97 VGND VGND VPWR VPWR sky130_fd_sc_hd__decap_3
XFILLER_32_53 VGND VGND VPWR VPWR sky130_fd_sc_hd__decap_6
XFILLER_12_146 VGND VGND VPWR VPWR sky130_fd_sc_hd__decap_4
XFILLER_12_113 VGND VGND VPWR VPWR sky130_fd_sc_hd__fill_1
XTAP_TAPCELL_ROW_8_106 VGND VPWR sky130_fd_sc_hd__tapvpwrvgnd_1
XPHY_EDGE_ROW_9_Right_9 VGND VGND VPWR VPWR sky130_fd_sc_hd__decap_3
X_462_ _069_ _023_ _068_ VGND VGND VPWR VPWR u_spi.tx_shift_q\[6\] sky130_fd_sc_hd__dfrtp_1
X_393_ clknet_2_1__leaf_clk _089_ net52 VGND VGND VPWR VPWR net25 sky130_fd_sc_hd__dfrtp_1
XFILLER_4_197 VGND VGND VPWR VPWR sky130_fd_sc_hd__decap_6
XFILLER_23_219 VGND VGND VPWR VPWR sky130_fd_sc_hd__fill_1
Xfanout56 net57 VGND VGND VPWR VPWR net56 sky130_fd_sc_hd__buf_2
Xfanout45 _042_ VGND VGND VPWR VPWR net45 sky130_fd_sc_hd__clkbuf_2
X_445_ _046_ net29 net62 VGND VGND VPWR VPWR u_spi.tx_snapshot_q\[4\] sky130_fd_sc_hd__dfrtp_1
X_376_ net65 VGND VGND VPWR VPWR _056_ sky130_fd_sc_hd__inv_2
XFILLER_24_98 VGND VGND VPWR VPWR sky130_fd_sc_hd__decap_8
X_230_ u_spi.tx_shift_q\[12\] u_spi.tx_snapshot_q\[12\] net38 VGND VGND VPWR VPWR
+ _015_ sky130_fd_sc_hd__mux2_1
X_428_ clknet_2_3__leaf_clk _112_ net61 VGND VGND VPWR VPWR sar_result_w\[3\] sky130_fd_sc_hd__dfrtp_1
X_359_ net45 net56 VGND VGND VPWR VPWR _038_ sky130_fd_sc_hd__and2_1
Xinput2 cs_n VGND VGND VPWR VPWR net2 sky130_fd_sc_hd__buf_1
XFILLER_36_141 VGND VGND VPWR VPWR sky130_fd_sc_hd__fill_2
XFILLER_10_23 VGND VGND VPWR VPWR sky130_fd_sc_hd__decap_4
XFILLER_27_185 VGND VGND VPWR VPWR sky130_fd_sc_hd__fill_1
X_213_ _128_ _135_ VGND VGND VPWR VPWR net36 sky130_fd_sc_hd__nor2_1
XFILLER_18_141 VGND VGND VPWR VPWR sky130_fd_sc_hd__decap_3
XFILLER_24_177 VPWR VGND VPWR VGND sky130_ef_sc_hd__decap_12
XFILLER_30_136 VGND VGND VPWR VPWR sky130_fd_sc_hd__fill_1
XTAP_TAPCELL_ROW_17_139 VGND VPWR sky130_fd_sc_hd__tapvpwrvgnd_1
XTAP_TAPCELL_ROW_31_186 VGND VPWR sky130_fd_sc_hd__tapvpwrvgnd_1
XFILLER_21_169 VPWR VGND VPWR VGND sky130_ef_sc_hd__decap_12
XFILLER_21_125 VGND VGND VPWR VPWR sky130_fd_sc_hd__decap_3
XTAP_TAPCELL_ROW_8_107 VGND VPWR sky130_fd_sc_hd__tapvpwrvgnd_1
XFILLER_35_206 VPWR VGND VPWR VGND sky130_ef_sc_hd__decap_12
XFILLER_11_180 VPWR VGND VPWR VGND sky130_ef_sc_hd__decap_12
XFILLER_7_140 VPWR VGND VPWR VGND sky130_ef_sc_hd__decap_12
XFILLER_7_162 VGND VGND VPWR VPWR sky130_fd_sc_hd__decap_6
XFILLER_32_209 VGND VGND VPWR VPWR sky130_fd_sc_hd__decap_8
X_461_ _067_ _022_ _066_ VGND VGND VPWR VPWR u_spi.tx_shift_q\[5\] sky130_fd_sc_hd__dfrtp_1
X_392_ net47 net54 VGND VGND VPWR VPWR _088_ sky130_fd_sc_hd__and2_1
XTAP_TAPCELL_ROW_10_112 VGND VPWR sky130_fd_sc_hd__tapvpwrvgnd_1
XPHY_EDGE_ROW_18_Left_55 VGND VGND VPWR VPWR sky130_fd_sc_hd__decap_3
Xfanout57 net64 VGND VGND VPWR VPWR net57 sky130_fd_sc_hd__clkbuf_2
Xfanout46 net47 VGND VGND VPWR VPWR net46 sky130_fd_sc_hd__clkbuf_2
XFILLER_14_209 VGND VGND VPWR VPWR sky130_fd_sc_hd__decap_6
XFILLER_1_113 VGND VGND VPWR VPWR sky130_fd_sc_hd__decap_6
X_444_ _045_ net28 net61 VGND VGND VPWR VPWR u_spi.tx_snapshot_q\[3\] sky130_fd_sc_hd__dfrtp_1
X_375_ net65 VGND VGND VPWR VPWR _055_ sky130_fd_sc_hd__inv_2
XFILLER_9_213 VGND VGND VPWR VPWR sky130_fd_sc_hd__decap_6
X_427_ clknet_2_3__leaf_clk net91 net61 VGND VGND VPWR VPWR sar_result_w\[2\] sky130_fd_sc_hd__dfrtp_1
X_358_ net45 net56 VGND VGND VPWR VPWR _037_ sky130_fd_sc_hd__and2_1
XFILLER_1_15 VPWR VGND VPWR VGND sky130_ef_sc_hd__decap_12
XFILLER_36_197 VPWR VGND VPWR VGND sky130_ef_sc_hd__decap_12
XPHY_EDGE_ROW_27_Right_27 VGND VGND VPWR VPWR sky130_fd_sc_hd__decap_3
XPHY_EDGE_ROW_18_Right_18 VGND VGND VPWR VPWR sky130_fd_sc_hd__decap_3
Xinput3 mosi VGND VGND VPWR VPWR net3 sky130_fd_sc_hd__buf_1
X_289_ u_spi.cmd_err_q u_spi.abort_err_q VGND VGND VPWR VPWR net21 sky130_fd_sc_hd__or2_1
XPHY_EDGE_ROW_36_Right_36 VGND VGND VPWR VPWR sky130_fd_sc_hd__decap_3
XFILLER_19_55 VGND VGND VPWR VPWR sky130_fd_sc_hd__fill_1
X_212_ net45 net54 VGND VGND VPWR VPWR _086_ sky130_fd_sc_hd__and2_1
XFILLER_24_189 VGND VGND VPWR VPWR sky130_fd_sc_hd__decap_6
XPHY_EDGE_ROW_6_Left_43 VGND VGND VPWR VPWR sky130_fd_sc_hd__decap_3
XTAP_TAPCELL_ROW_31_187 VGND VPWR sky130_fd_sc_hd__tapvpwrvgnd_1
XFILLER_29_204 VPWR VGND VPWR VGND sky130_ef_sc_hd__decap_12
XFILLER_21_148 VPWR VGND VPWR VGND sky130_ef_sc_hd__decap_12
XTAP_TAPCELL_ROW_8_108 VGND VPWR sky130_fd_sc_hd__tapvpwrvgnd_1
XFILLER_35_218 VGND VGND VPWR VPWR sky130_fd_sc_hd__fill_2
XPHY_EDGE_ROW_32_Left_69 VGND VGND VPWR VPWR sky130_fd_sc_hd__decap_3
XTAP_TAPCELL_ROW_22_154 VGND VPWR sky130_fd_sc_hd__tapvpwrvgnd_1
XFILLER_20_181 VGND VGND VPWR VPWR sky130_fd_sc_hd__fill_1
XPHY_EDGE_ROW_0_Right_0 VGND VGND VPWR VPWR sky130_fd_sc_hd__decap_3
XFILLER_11_192 VPWR VGND VPWR VGND sky130_ef_sc_hd__decap_12
XFILLER_7_152 VGND VGND VPWR VPWR sky130_fd_sc_hd__decap_6
X_460_ _065_ _021_ _064_ VGND VGND VPWR VPWR u_spi.tx_shift_q\[4\] sky130_fd_sc_hd__dfrtp_1
XFILLER_27_55 VGND VGND VPWR VPWR sky130_fd_sc_hd__fill_1
X_391_ net48 VGND VGND VPWR VPWR _087_ sky130_fd_sc_hd__inv_2
XTAP_TAPCELL_ROW_10_113 VGND VPWR sky130_fd_sc_hd__tapvpwrvgnd_1
XFILLER_4_15 VPWR VGND VPWR VGND sky130_ef_sc_hd__decap_12
XTAP_TAPCELL_ROW_4_91 VGND VPWR sky130_fd_sc_hd__tapvpwrvgnd_1
XFILLER_4_166 VGND VGND VPWR VPWR sky130_fd_sc_hd__fill_1
Xfanout58 net64 VGND VGND VPWR VPWR net58 sky130_fd_sc_hd__clkbuf_4
Xfanout47 _042_ VGND VGND VPWR VPWR net47 sky130_fd_sc_hd__clkbuf_2
XFILLER_13_57 VPWR VGND VPWR VGND sky130_ef_sc_hd__decap_12
XFILLER_1_147 VGND VGND VPWR VPWR sky130_fd_sc_hd__decap_8
XPHY_EDGE_ROW_35_Left_72 VGND VGND VPWR VPWR sky130_fd_sc_hd__decap_3
X_443_ _044_ net27 net60 VGND VGND VPWR VPWR u_spi.tx_snapshot_q\[2\] sky130_fd_sc_hd__dfrtp_1
X_374_ net65 VGND VGND VPWR VPWR _054_ sky130_fd_sc_hd__inv_2
XFILLER_24_56 VGND VGND VPWR VPWR sky130_fd_sc_hd__fill_1
XFILLER_1_27 VPWR VGND VPWR VGND sky130_ef_sc_hd__decap_12
XFILLER_6_3 VPWR VGND VPWR VGND sky130_ef_sc_hd__decap_12
XFILLER_36_154 VGND VGND VPWR VPWR sky130_fd_sc_hd__decap_3
XFILLER_36_121 VGND VGND VPWR VPWR sky130_fd_sc_hd__fill_1
Xinput4 rst_n VGND VGND VPWR VPWR net4 sky130_fd_sc_hd__clkbuf_1
X_426_ clknet_2_3__leaf_clk _110_ net58 VGND VGND VPWR VPWR sar_result_w\[1\] sky130_fd_sc_hd__dfrtp_1
X_288_ net117 net68 VGND VGND VPWR VPWR _011_ sky130_fd_sc_hd__xor2_2
X_357_ net47 net52 VGND VGND VPWR VPWR _036_ sky130_fd_sc_hd__and2_1
XTAP_TAPCELL_ROW_1_81 VGND VPWR sky130_fd_sc_hd__tapvpwrvgnd_1
Xclkbuf_2_1__f_clk clknet_0_clk VGND VGND VPWR VPWR clknet_2_1__leaf_clk sky130_fd_sc_hd__clkbuf_16
XFILLER_27_132 VPWR VGND VPWR VGND sky130_ef_sc_hd__decap_12
XFILLER_27_110 VGND VGND VPWR VPWR sky130_fd_sc_hd__fill_2
X_211_ u_spi.start_bit_w _139_ _140_ u_spi.cmd_err_q VGND VGND VPWR VPWR _119_ sky130_fd_sc_hd__a31o_1
XFILLER_18_121 VGND VGND VPWR VPWR sky130_fd_sc_hd__decap_8
X_409_ net50 u_spi.ch_addr_w\[2\] _035_ VGND VGND VPWR VPWR u_spi.sgl_bit_w sky130_fd_sc_hd__dfrtp_1
XTAP_TAPCELL_ROW_34_196 VGND VPWR sky130_fd_sc_hd__tapvpwrvgnd_1
XFILLER_21_13 VPWR VGND VPWR VGND sky130_ef_sc_hd__decap_12
XFILLER_30_105 VPWR VGND VPWR VGND sky130_ef_sc_hd__decap_12
XFILLER_15_179 VPWR VGND VPWR VGND sky130_ef_sc_hd__decap_12
XFILLER_7_15 VGND VGND VPWR VPWR sky130_fd_sc_hd__decap_8
XTAP_TAPCELL_ROW_31_188 VGND VPWR sky130_fd_sc_hd__tapvpwrvgnd_1
XFILLER_29_216 VGND VGND VPWR VPWR sky130_fd_sc_hd__decap_4
XTAP_TAPCELL_ROW_22_155 VGND VPWR sky130_fd_sc_hd__tapvpwrvgnd_1
XFILLER_20_193 VGND VGND VPWR VPWR sky130_fd_sc_hd__decap_3
XTAP_TAPCELL_ROW_36_203 VGND VPWR sky130_fd_sc_hd__tapvpwrvgnd_1
XFILLER_11_160 VGND VGND VPWR VPWR sky130_fd_sc_hd__decap_8
XFILLER_27_78 VPWR VGND VPWR VGND sky130_ef_sc_hd__decap_12
X_390_ net48 VGND VGND VPWR VPWR _085_ sky130_fd_sc_hd__inv_2
XFILLER_4_27 VGND VGND VPWR VPWR sky130_fd_sc_hd__fill_1
XFILLER_4_49 VGND VGND VPWR VPWR sky130_fd_sc_hd__fill_1
XTAP_TAPCELL_ROW_10_114 VGND VPWR sky130_fd_sc_hd__tapvpwrvgnd_1
Xfanout59 net64 VGND VGND VPWR VPWR net59 sky130_fd_sc_hd__clkbuf_2
Xfanout37 _144_ VGND VGND VPWR VPWR net37 sky130_fd_sc_hd__buf_2
XFILLER_13_69 VGND VGND VPWR VPWR sky130_fd_sc_hd__fill_1
Xfanout48 net49 VGND VGND VPWR VPWR net48 sky130_fd_sc_hd__clkbuf_4
XTAP_TAPCELL_ROW_4_92 VGND VPWR sky130_fd_sc_hd__tapvpwrvgnd_1
X_442_ _043_ net26 net63 VGND VGND VPWR VPWR u_spi.tx_snapshot_q\[1\] sky130_fd_sc_hd__dfrtp_1
X_373_ net65 VGND VGND VPWR VPWR _053_ sky130_fd_sc_hd__inv_2
XFILLER_6_218 VGND VGND VPWR VPWR sky130_fd_sc_hd__fill_2
Xinput5 sclk VGND VGND VPWR VPWR net5 sky130_fd_sc_hd__clkbuf_2
X_287_ net36 _185_ _186_ _144_ VGND VGND VPWR VPWR _009_ sky130_fd_sc_hd__o31a_1
X_425_ clknet_2_1__leaf_clk _109_ net53 VGND VGND VPWR VPWR sar_result_w\[0\] sky130_fd_sc_hd__dfrtp_1
XTAP_TAPCELL_ROW_1_82 VGND VPWR sky130_fd_sc_hd__tapvpwrvgnd_1
XFILLER_1_39 VPWR VGND VPWR VGND sky130_ef_sc_hd__decap_12
X_356_ net47 net52 VGND VGND VPWR VPWR _035_ sky130_fd_sc_hd__and2_1
XFILLER_27_144 VPWR VGND VPWR VGND sky130_ef_sc_hd__decap_12
XFILLER_33_169 VGND VGND VPWR VPWR sky130_fd_sc_hd__decap_4
XFILLER_33_147 VGND VGND VPWR VPWR sky130_fd_sc_hd__decap_4
X_408_ net50 u_spi.ch_addr_w\[1\] _034_ VGND VGND VPWR VPWR u_spi.ch_addr_w\[2\] sky130_fd_sc_hd__dfrtp_1
X_210_ net3 net6 u_spi.sgl_bit_w VGND VGND VPWR VPWR _140_ sky130_fd_sc_hd__a21bo_1
XTAP_TAPCELL_ROW_34_197 VGND VPWR sky130_fd_sc_hd__tapvpwrvgnd_1
XFILLER_2_71 VGND VGND VPWR VPWR sky130_fd_sc_hd__decap_4
X_339_ net45 net54 VGND VGND VPWR VPWR _082_ sky130_fd_sc_hd__and2_1
XFILLER_30_117 VGND VGND VPWR VPWR sky130_fd_sc_hd__decap_4
XFILLER_21_69 VGND VGND VPWR VPWR sky130_fd_sc_hd__decap_4
XFILLER_21_25 VPWR VGND VPWR VGND sky130_ef_sc_hd__decap_12
XFILLER_15_169 VGND VGND VPWR VPWR sky130_fd_sc_hd__decap_6
XFILLER_23_7 VPWR VGND VPWR VGND sky130_ef_sc_hd__decap_12
XFILLER_32_79 VGND VGND VPWR VPWR sky130_fd_sc_hd__decap_4
XTAP_TAPCELL_ROW_22_156 VGND VPWR sky130_fd_sc_hd__tapvpwrvgnd_1
XTAP_TAPCELL_ROW_13_123 VGND VPWR sky130_fd_sc_hd__tapvpwrvgnd_1
XFILLER_14_3 VPWR VGND VPWR VGND sky130_ef_sc_hd__decap_12
XFILLER_7_121 VGND VGND VPWR VPWR sky130_fd_sc_hd__fill_2
XTAP_TAPCELL_ROW_36_204 VGND VPWR sky130_fd_sc_hd__tapvpwrvgnd_1
XFILLER_27_57 VPWR VGND VPWR VGND sky130_ef_sc_hd__decap_12
XTAP_TAPCELL_ROW_10_115 VGND VPWR sky130_fd_sc_hd__tapvpwrvgnd_1
Xfanout49 net50 VGND VGND VPWR VPWR net49 sky130_fd_sc_hd__clkbuf_4
Xfanout38 _142_ VGND VGND VPWR VPWR net38 sky130_fd_sc_hd__clkbuf_4
XFILLER_13_15 VPWR VGND VPWR VGND sky130_ef_sc_hd__decap_12
XFILLER_3_190 VPWR VGND VPWR VGND sky130_ef_sc_hd__decap_12
XTAP_TAPCELL_ROW_4_93 VGND VPWR sky130_fd_sc_hd__tapvpwrvgnd_1
X_441_ net47 net25 net56 VGND VGND VPWR VPWR u_spi.tx_snapshot_q\[0\] sky130_fd_sc_hd__dfrtp_1
X_372_ net65 VGND VGND VPWR VPWR _052_ sky130_fd_sc_hd__inv_2
X_286_ net20 _152_ VGND VGND VPWR VPWR _186_ sky130_fd_sc_hd__and2_1
XTAP_TAPCELL_ROW_1_83 VGND VPWR sky130_fd_sc_hd__tapvpwrvgnd_1
X_355_ net47 net51 VGND VGND VPWR VPWR _034_ sky130_fd_sc_hd__and2_1
X_424_ clknet_2_0__leaf_clk u_spi.start_toggle_q net52 VGND VGND VPWR VPWR u_spi.sync_toggle_q1
+ sky130_fd_sc_hd__dfrtp_1
XFILLER_36_167 VGND VGND VPWR VPWR sky130_fd_sc_hd__fill_1
XFILLER_10_27 VGND VGND VPWR VPWR sky130_fd_sc_hd__fill_1
XFILLER_10_49 VPWR VGND VPWR VGND sky130_ef_sc_hd__decap_12
XFILLER_35_57 VGND VGND VPWR VPWR sky130_fd_sc_hd__decap_4
XFILLER_35_35 VGND VGND VPWR VPWR sky130_fd_sc_hd__fill_1
XFILLER_27_156 VPWR VGND VPWR VGND sky130_ef_sc_hd__decap_12
XPHY_EDGE_ROW_23_Right_23 VGND VGND VPWR VPWR sky130_fd_sc_hd__decap_3
XPHY_EDGE_ROW_14_Right_14 VGND VGND VPWR VPWR sky130_fd_sc_hd__decap_3
XPHY_EDGE_ROW_32_Right_32 VGND VGND VPWR VPWR sky130_fd_sc_hd__decap_3
X_269_ _158_ _174_ net37 VGND VGND VPWR VPWR _003_ sky130_fd_sc_hd__a21boi_1
XFILLER_24_137 VGND VGND VPWR VPWR sky130_fd_sc_hd__decap_3
XFILLER_24_126 VGND VGND VPWR VPWR sky130_fd_sc_hd__fill_2
XFILLER_2_94 VGND VGND VPWR VPWR sky130_fd_sc_hd__decap_4
X_407_ net50 u_spi.ch_addr_w\[0\] _033_ VGND VGND VPWR VPWR u_spi.ch_addr_w\[1\] sky130_fd_sc_hd__dfrtp_1
X_338_ net45 net54 VGND VGND VPWR VPWR _084_ sky130_fd_sc_hd__and2_1
XTAP_TAPCELL_ROW_34_198 VGND VPWR sky130_fd_sc_hd__tapvpwrvgnd_1
XTAP_TAPCELL_ROW_25_165 VGND VPWR sky130_fd_sc_hd__tapvpwrvgnd_1
XFILLER_23_181 VGND VGND VPWR VPWR sky130_fd_sc_hd__decap_6
XFILLER_21_37 VGND VGND VPWR VPWR sky130_fd_sc_hd__decap_6
XFILLER_16_7 VPWR VGND VPWR VGND sky130_ef_sc_hd__decap_12
XTAP_TAPCELL_ROW_22_157 VGND VPWR sky130_fd_sc_hd__tapvpwrvgnd_1
XTAP_TAPCELL_ROW_13_124 VGND VPWR sky130_fd_sc_hd__tapvpwrvgnd_1
XTAP_TAPCELL_ROW_36_205 VGND VPWR sky130_fd_sc_hd__tapvpwrvgnd_1
XPHY_EDGE_ROW_4_Right_4 VGND VGND VPWR VPWR sky130_fd_sc_hd__decap_3
XFILLER_8_82 VGND VGND VPWR VPWR sky130_fd_sc_hd__fill_2
XFILLER_27_69 VGND VGND VPWR VPWR sky130_fd_sc_hd__decap_4
XFILLER_27_47 VGND VGND VPWR VPWR sky130_fd_sc_hd__decap_8
XTAP_TAPCELL_ROW_4_94 VGND VPWR sky130_fd_sc_hd__tapvpwrvgnd_1
Xfanout39 _142_ VGND VGND VPWR VPWR net39 sky130_fd_sc_hd__clkbuf_2
X_371_ net65 VGND VGND VPWR VPWR _051_ sky130_fd_sc_hd__inv_2
X_440_ clknet_2_0__leaf_clk _011_ net52 VGND VGND VPWR VPWR conv_start_w sky130_fd_sc_hd__dfrtp_1
XFILLER_13_27 VGND VGND VPWR VPWR sky130_fd_sc_hd__decap_8
XFILLER_24_15 VPWR VGND VPWR VGND sky130_ef_sc_hd__decap_12
X_285_ _152_ _155_ _162_ VGND VGND VPWR VPWR _185_ sky130_fd_sc_hd__a21oi_1
XFILLER_14_70 VPWR VGND VPWR VGND sky130_ef_sc_hd__decap_12
X_354_ net47 net51 VGND VGND VPWR VPWR _033_ sky130_fd_sc_hd__and2_1
X_423_ net65 _010_ net55 VGND VGND VPWR VPWR u_spi.abort_err_q sky130_fd_sc_hd__dfrtp_1
XFILLER_36_113 VGND VGND VPWR VPWR sky130_fd_sc_hd__decap_4
XFILLER_27_113 VGND VGND VPWR VPWR sky130_fd_sc_hd__decap_6
XFILLER_27_102 VGND VGND VPWR VPWR sky130_fd_sc_hd__decap_8
XFILLER_19_15 VGND VGND VPWR VPWR sky130_fd_sc_hd__fill_1
XFILLER_4_3 VPWR VGND VPWR VGND sky130_ef_sc_hd__decap_12
X_268_ _161_ _173_ _170_ _132_ VGND VGND VPWR VPWR _174_ sky130_fd_sc_hd__o2bb2a_1
X_337_ _147_ _158_ VGND VGND VPWR VPWR _127_ sky130_fd_sc_hd__nand2_1
X_199_ net12 VGND VGND VPWR VPWR _131_ sky130_fd_sc_hd__inv_2
X_406_ net50 net3 _032_ VGND VGND VPWR VPWR u_spi.ch_addr_w\[0\] sky130_fd_sc_hd__dfrtp_1
XTAP_TAPCELL_ROW_34_199 VGND VPWR sky130_fd_sc_hd__tapvpwrvgnd_1
XFILLER_32_193 VGND VGND VPWR VPWR sky130_fd_sc_hd__decap_3
XTAP_TAPCELL_ROW_25_166 VGND VPWR sky130_fd_sc_hd__tapvpwrvgnd_1
XTAP_TAPCELL_ROW_16_133 VGND VPWR sky130_fd_sc_hd__tapvpwrvgnd_1
XFILLER_11_71 VGND VGND VPWR VPWR sky130_fd_sc_hd__fill_2
XFILLER_11_82 VGND VGND VPWR VPWR sky130_fd_sc_hd__decap_3
XFILLER_32_15 VPWR VGND VPWR VGND sky130_ef_sc_hd__decap_12
XPHY_EDGE_ROW_26_Left_63 VGND VGND VPWR VPWR sky130_fd_sc_hd__decap_3
XFILLER_20_141 VGND VGND VPWR VPWR sky130_fd_sc_hd__fill_2
XFILLER_16_27 VGND VGND VPWR VPWR sky130_fd_sc_hd__fill_1
XFILLER_14_193 VGND VGND VPWR VPWR sky130_fd_sc_hd__decap_3
XPHY_EDGE_ROW_10_Left_47 VGND VGND VPWR VPWR sky130_fd_sc_hd__decap_3
XFILLER_20_185 VGND VGND VPWR VPWR sky130_fd_sc_hd__decap_8
XTAP_TAPCELL_ROW_13_125 VGND VPWR sky130_fd_sc_hd__tapvpwrvgnd_1
XTAP_TAPCELL_ROW_36_206 VGND VPWR sky130_fd_sc_hd__tapvpwrvgnd_1
XFILLER_27_15 VGND VGND VPWR VPWR sky130_fd_sc_hd__decap_4
XFILLER_31_203 VPWR VGND VPWR VGND sky130_ef_sc_hd__decap_12
XFILLER_22_214 VGND VGND VPWR VPWR sky130_fd_sc_hd__fill_2
XPHY_EDGE_ROW_13_Left_50 VGND VGND VPWR VPWR sky130_fd_sc_hd__decap_3
XFILLER_28_91 VPWR VGND VPWR VGND sky130_ef_sc_hd__decap_12
X_370_ net66 VGND VGND VPWR VPWR _050_ sky130_fd_sc_hd__inv_2
XFILLER_0_195 VGND VGND VPWR VPWR sky130_fd_sc_hd__fill_1
XFILLER_24_27 VGND VGND VPWR VPWR sky130_fd_sc_hd__fill_1
XFILLER_5_95 VGND VGND VPWR VPWR sky130_fd_sc_hd__decap_4
X_284_ _152_ _184_ _144_ VGND VGND VPWR VPWR _008_ sky130_fd_sc_hd__a21boi_1
X_353_ net47 net51 VGND VGND VPWR VPWR _032_ sky130_fd_sc_hd__and2_1
X_422_ clknet_2_0__leaf_clk net67 net52 VGND VGND VPWR VPWR u_spi.sync_toggle_q2 sky130_fd_sc_hd__dfrtp_1
XFILLER_10_217 VGND VGND VPWR VPWR sky130_fd_sc_hd__decap_3
XFILLER_36_169 VPWR VGND VPWR VGND sky130_ef_sc_hd__decap_12
XFILLER_36_147 VGND VGND VPWR VPWR sky130_fd_sc_hd__decap_3
XFILLER_14_82 VGND VGND VPWR VPWR sky130_fd_sc_hd__fill_2
XFILLER_35_15 VPWR VGND VPWR VGND sky130_ef_sc_hd__decap_12
XFILLER_27_169 VPWR VGND VPWR VGND sky130_ef_sc_hd__decap_12
XFILLER_19_49 VGND VGND VPWR VPWR sky130_fd_sc_hd__fill_2
XTAP_TAPCELL_ROW_28_175 VGND VPWR sky130_fd_sc_hd__tapvpwrvgnd_1
X_336_ _192_ VGND VGND VPWR VPWR _126_ sky130_fd_sc_hd__inv_2
X_198_ net1 VGND VGND VPWR VPWR _130_ sky130_fd_sc_hd__inv_2
X_267_ net1 _141_ _155_ _166_ VGND VGND VPWR VPWR _173_ sky130_fd_sc_hd__and4_1
X_405_ clknet_2_1__leaf_clk net114 net54 VGND VGND VPWR VPWR net24 sky130_fd_sc_hd__dfrtp_1
XFILLER_32_161 VPWR VGND VPWR VGND sky130_ef_sc_hd__decap_12
XTAP_TAPCELL_ROW_25_167 VGND VPWR sky130_fd_sc_hd__tapvpwrvgnd_1
X_319_ net81 net1 net40 VGND VGND VPWR VPWR _109_ sky130_fd_sc_hd__mux2_1
XTAP_TAPCELL_ROW_16_134 VGND VPWR sky130_fd_sc_hd__tapvpwrvgnd_1
XFILLER_32_27 VGND VGND VPWR VPWR sky130_fd_sc_hd__fill_1
XFILLER_20_175 VGND VGND VPWR VPWR sky130_fd_sc_hd__decap_6
XFILLER_12_109 VGND VGND VPWR VPWR sky130_fd_sc_hd__decap_4
XTAP_TAPCELL_ROW_7_102 VGND VPWR sky130_fd_sc_hd__tapvpwrvgnd_1
XTAP_TAPCELL_ROW_36_207 VGND VPWR sky130_fd_sc_hd__tapvpwrvgnd_1
XFILLER_11_142 VGND VGND VPWR VPWR sky130_fd_sc_hd__fill_2
XFILLER_7_113 VGND VGND VPWR VPWR sky130_fd_sc_hd__decap_8
XFILLER_31_215 VGND VGND VPWR VPWR sky130_fd_sc_hd__decap_4
XFILLER_4_138 VGND VGND VPWR VPWR sky130_fd_sc_hd__fill_2
XFILLER_1_119 VGND VGND VPWR VPWR sky130_fd_sc_hd__fill_1
XFILLER_0_141 VPWR VGND VPWR VGND sky130_ef_sc_hd__decap_12
XFILLER_9_219 VGND VGND VPWR VPWR sky130_fd_sc_hd__fill_1
X_421_ clknet_2_0__leaf_clk net68 net52 VGND VGND VPWR VPWR u_spi.sync_toggle_q3 sky130_fd_sc_hd__dfrtp_1
XFILLER_30_93 VPWR VGND VPWR VGND sky130_ef_sc_hd__decap_12
X_283_ net19 _151_ _160_ _175_ VGND VGND VPWR VPWR _184_ sky130_fd_sc_hd__a22oi_1
X_352_ net65 VGND VGND VPWR VPWR _193_ sky130_fd_sc_hd__buf_1
XFILLER_35_27 VGND VGND VPWR VPWR sky130_fd_sc_hd__decap_8
XFILLER_19_39 VGND VGND VPWR VPWR sky130_fd_sc_hd__decap_3
X_266_ net37 _172_ VGND VGND VPWR VPWR _002_ sky130_fd_sc_hd__and2_1
XTAP_TAPCELL_ROW_28_176 VGND VPWR sky130_fd_sc_hd__tapvpwrvgnd_1
XFILLER_26_181 VPWR VGND VPWR VGND sky130_ef_sc_hd__decap_12
X_335_ net43 _153_ _146_ VGND VGND VPWR VPWR _192_ sky130_fd_sc_hd__mux2_1
XFILLER_18_137 VGND VGND VPWR VPWR sky130_fd_sc_hd__decap_3
XFILLER_18_115 VGND VGND VPWR VPWR sky130_fd_sc_hd__fill_2
X_197_ u_spi.bit_count_q\[0\] VGND VGND VPWR VPWR _027_ sky130_fd_sc_hd__inv_2
X_404_ clknet_2_1__leaf_clk net112 net54 VGND VGND VPWR VPWR net23 sky130_fd_sc_hd__dfrtp_1
XFILLER_32_173 VPWR VGND VPWR VGND sky130_ef_sc_hd__decap_12
XFILLER_2_75 VGND VGND VPWR VPWR sky130_fd_sc_hd__fill_1
XPHY_EDGE_ROW_10_Right_10 VGND VGND VPWR VPWR sky130_fd_sc_hd__decap_3
X_249_ net43 u_sar_core.state_q\[3\] _130_ _129_ net44 VGND VGND VPWR VPWR _157_ sky130_fd_sc_hd__a2111o_1
XTAP_TAPCELL_ROW_16_135 VGND VPWR sky130_fd_sc_hd__tapvpwrvgnd_1
X_318_ u_spi.req_channel_q\[2\] u_spi.ch_addr_w\[2\] _191_ VGND VGND VPWR VPWR _108_
+ sky130_fd_sc_hd__mux2_1
XTAP_TAPCELL_ROW_30_182 VGND VPWR sky130_fd_sc_hd__tapvpwrvgnd_1
XFILLER_16_29 VGND VGND VPWR VPWR sky130_fd_sc_hd__decap_3
XTAP_TAPCELL_ROW_7_103 VGND VPWR sky130_fd_sc_hd__tapvpwrvgnd_1
XTAP_TAPCELL_ROW_36_208 VGND VPWR sky130_fd_sc_hd__tapvpwrvgnd_1
XFILLER_22_83 VGND VGND VPWR VPWR sky130_fd_sc_hd__fill_1
XFILLER_22_61 VGND VGND VPWR VPWR sky130_fd_sc_hd__fill_1
XFILLER_7_158 VGND VGND VPWR VPWR sky130_fd_sc_hd__fill_1
XFILLER_7_169 VPWR VGND VPWR VGND sky130_ef_sc_hd__decap_12
XFILLER_11_110 VGND VGND VPWR VPWR sky130_fd_sc_hd__fill_2
XFILLER_8_41 VGND VGND VPWR VPWR sky130_fd_sc_hd__decap_3
XFILLER_8_85 VPWR VGND VPWR VGND sky130_ef_sc_hd__decap_12
XPHY_EDGE_ROW_8_Right_8 VGND VGND VPWR VPWR sky130_fd_sc_hd__decap_3
Xhold1 u_spi.sync_toggle_q1 VGND VGND VPWR VPWR net67 sky130_fd_sc_hd__dlygate4sd3_1
XFILLER_0_197 VPWR VGND VPWR VGND sky130_ef_sc_hd__decap_12
XFILLER_0_175 VPWR VGND VPWR VGND sky130_ef_sc_hd__decap_12
XFILLER_0_153 VPWR VGND VPWR VGND sky130_ef_sc_hd__decap_12
XFILLER_24_29 VPWR VGND VPWR VGND sky130_ef_sc_hd__decap_12
XFILLER_36_105 VGND VGND VPWR VPWR sky130_fd_sc_hd__decap_3
XFILLER_30_83 VGND VGND VPWR VPWR sky130_fd_sc_hd__fill_1
X_282_ _182_ _183_ _144_ VGND VGND VPWR VPWR _007_ sky130_fd_sc_hd__o21a_1
X_351_ net46 net56 VGND VGND VPWR VPWR _058_ sky130_fd_sc_hd__and2_1
X_420_ clknet_2_1__leaf_clk u_spi.req_channel_q\[2\] net53 VGND VGND VPWR VPWR u_spi.channel_sync_q\[2\]
+ sky130_fd_sc_hd__dfrtp_1
XFILLER_35_182 VPWR VGND VPWR VGND sky130_ef_sc_hd__decap_12
XTAP_TAPCELL_ROW_28_177 VGND VPWR sky130_fd_sc_hd__tapvpwrvgnd_1
XFILLER_26_193 VGND VGND VPWR VPWR sky130_fd_sc_hd__decap_3
XFILLER_25_61 VGND VGND VPWR VPWR sky130_fd_sc_hd__fill_1
X_334_ net36 _167_ VGND VGND VPWR VPWR _125_ sky130_fd_sc_hd__nand2b_1
X_403_ clknet_2_1__leaf_clk net116 net52 VGND VGND VPWR VPWR net22 sky130_fd_sc_hd__dfrtp_1
XFILLER_32_185 VGND VGND VPWR VPWR sky130_fd_sc_hd__decap_8
X_265_ _161_ _169_ _170_ _171_ VGND VGND VPWR VPWR _172_ sky130_fd_sc_hd__a211o_1
XTAP_TAPCELL_ROW_19_144 VGND VPWR sky130_fd_sc_hd__tapvpwrvgnd_1
X_196_ net65 VGND VGND VPWR VPWR _042_ sky130_fd_sc_hd__inv_2
XFILLER_2_98 VGND VGND VPWR VPWR sky130_fd_sc_hd__fill_1
XFILLER_36_93 VGND VGND VPWR VPWR sky130_fd_sc_hd__fill_1
X_248_ _152_ _155_ VGND VGND VPWR VPWR _156_ sky130_fd_sc_hd__nand2_1
XTAP_TAPCELL_ROW_16_136 VGND VPWR sky130_fd_sc_hd__tapvpwrvgnd_1
XFILLER_14_185 VGND VGND VPWR VPWR sky130_fd_sc_hd__decap_8
XFILLER_2_3 VPWR VGND VPWR VGND sky130_ef_sc_hd__decap_12
X_317_ u_spi.req_channel_q\[1\] u_spi.ch_addr_w\[1\] _191_ VGND VGND VPWR VPWR _107_
+ sky130_fd_sc_hd__mux2_1
XFILLER_35_3 VPWR VGND VPWR VGND sky130_ef_sc_hd__decap_12
XFILLER_32_29 VPWR VGND VPWR VGND sky130_ef_sc_hd__decap_12
XTAP_TAPCELL_ROW_30_183 VGND VPWR sky130_fd_sc_hd__tapvpwrvgnd_1
XFILLER_16_19 VGND VGND VPWR VPWR sky130_fd_sc_hd__decap_8
XTAP_TAPCELL_ROW_7_104 VGND VPWR sky130_fd_sc_hd__tapvpwrvgnd_1
Xclkbuf_2_2__f_clk clknet_0_clk VGND VGND VPWR VPWR clknet_2_2__leaf_clk sky130_fd_sc_hd__clkbuf_16
XTAP_TAPCELL_ROW_36_209 VGND VPWR sky130_fd_sc_hd__tapvpwrvgnd_1
XFILLER_25_214 VGND VGND VPWR VPWR sky130_fd_sc_hd__fill_2
XFILLER_6_181 VGND VGND VPWR VPWR sky130_fd_sc_hd__fill_1
XFILLER_8_97 VGND VGND VPWR VPWR sky130_fd_sc_hd__decap_6
XFILLER_17_95 VPWR VGND VPWR VGND sky130_ef_sc_hd__decap_12
XFILLER_16_203 VPWR VGND VPWR VGND sky130_ef_sc_hd__decap_12
XFILLER_4_118 VGND VGND VPWR VPWR sky130_fd_sc_hd__decap_3
XFILLER_22_206 VGND VGND VPWR VPWR sky130_fd_sc_hd__decap_8
Xhold2 u_spi.sync_toggle_q2 VGND VGND VPWR VPWR net68 sky130_fd_sc_hd__dlygate4sd3_1
XFILLER_0_187 VGND VGND VPWR VPWR sky130_fd_sc_hd__decap_8
XFILLER_0_165 VGND VGND VPWR VPWR sky130_fd_sc_hd__decap_3
XPHY_EDGE_ROW_17_Left_54 VGND VGND VPWR VPWR sky130_fd_sc_hd__decap_3
XFILLER_5_65 VGND VGND VPWR VPWR sky130_fd_sc_hd__fill_2
XFILLER_10_209 VGND VGND VPWR VPWR sky130_fd_sc_hd__decap_8
X_281_ _133_ _145_ _160_ _173_ VGND VGND VPWR VPWR _183_ sky130_fd_sc_hd__a22o_1
X_350_ net46 net60 VGND VGND VPWR VPWR _060_ sky130_fd_sc_hd__and2_1
XFILLER_14_85 VGND VGND VPWR VPWR sky130_fd_sc_hd__decap_4
XFILLER_14_41 VGND VGND VPWR VPWR sky130_fd_sc_hd__decap_6
X_479_ clknet_2_2__leaf_clk _003_ net59 VGND VGND VPWR VPWR net14 sky130_fd_sc_hd__dfrtp_1
XFILLER_35_194 VPWR VGND VPWR VGND sky130_ef_sc_hd__decap_12
XFILLER_35_161 VGND VGND VPWR VPWR sky130_fd_sc_hd__fill_1
XPHY_EDGE_ROW_2_Left_39 VGND VGND VPWR VPWR sky130_fd_sc_hd__decap_3
X_264_ _147_ _163_ net13 VGND VGND VPWR VPWR _171_ sky130_fd_sc_hd__o21a_1
XTAP_TAPCELL_ROW_28_178 VGND VPWR sky130_fd_sc_hd__tapvpwrvgnd_1
X_195_ u_sar_core.state_q\[1\] VGND VGND VPWR VPWR _129_ sky130_fd_sc_hd__inv_2
XTAP_TAPCELL_ROW_19_145 VGND VPWR sky130_fd_sc_hd__tapvpwrvgnd_1
X_402_ clknet_2_1__leaf_clk net88 net56 VGND VGND VPWR VPWR net34 sky130_fd_sc_hd__dfrtp_1
X_333_ net110 _135_ _141_ _128_ VGND VGND VPWR VPWR _124_ sky130_fd_sc_hd__o211a_1
XFILLER_32_197 VPWR VGND VPWR VGND sky130_ef_sc_hd__decap_12
X_247_ _135_ _141_ _146_ _154_ VGND VGND VPWR VPWR _155_ sky130_fd_sc_hd__a31o_1
XFILLER_14_197 VGND VGND VPWR VPWR sky130_fd_sc_hd__decap_3
X_316_ u_spi.req_channel_q\[0\] u_spi.ch_addr_w\[0\] _191_ VGND VGND VPWR VPWR _106_
+ sky130_fd_sc_hd__mux2_1
XTAP_TAPCELL_ROW_30_184 VGND VPWR sky130_fd_sc_hd__tapvpwrvgnd_1
XFILLER_28_3 VPWR VGND VPWR VGND sky130_ef_sc_hd__decap_12
XFILLER_22_85 VPWR VGND VPWR VGND sky130_ef_sc_hd__decap_12
XTAP_TAPCELL_ROW_21_151 VGND VPWR sky130_fd_sc_hd__tapvpwrvgnd_1
XFILLER_11_134 VGND VGND VPWR VPWR sky130_fd_sc_hd__fill_2
XPHY_EDGE_ROW_5_Left_42 VGND VGND VPWR VPWR sky130_fd_sc_hd__decap_3
XPHY_EDGE_ROW_31_Left_68 VGND VGND VPWR VPWR sky130_fd_sc_hd__decap_3
XFILLER_33_51 VGND VGND VPWR VPWR sky130_fd_sc_hd__decap_4
XFILLER_16_215 VGND VGND VPWR VPWR sky130_fd_sc_hd__decap_4
XFILLER_3_130 VGND VGND VPWR VPWR sky130_fd_sc_hd__fill_1
Xhold3 u_spi.channel_sync_q\[1\] VGND VGND VPWR VPWR net69 sky130_fd_sc_hd__dlygate4sd3_1
XFILLER_28_51 VGND VGND VPWR VPWR sky130_fd_sc_hd__decap_6
XFILLER_0_133 VGND VGND VPWR VPWR sky130_fd_sc_hd__decap_3
XFILLER_5_55 VGND VGND VPWR VPWR sky130_fd_sc_hd__fill_1
XFILLER_5_99 VGND VGND VPWR VPWR sky130_fd_sc_hd__fill_1
X_280_ _136_ _153_ net18 VGND VGND VPWR VPWR _182_ sky130_fd_sc_hd__o21a_1
XPHY_EDGE_ROW_34_Left_71 VGND VGND VPWR VPWR sky130_fd_sc_hd__decap_3
X_478_ clknet_2_2__leaf_clk _002_ net59 VGND VGND VPWR VPWR net13 sky130_fd_sc_hd__dfrtp_1
XFILLER_30_85 VGND VGND VPWR VPWR sky130_fd_sc_hd__decap_4
XFILLER_29_192 VPWR VGND VPWR VGND sky130_ef_sc_hd__decap_12
XFILLER_2_217 VGND VGND VPWR VPWR sky130_fd_sc_hd__decap_3
X_263_ _136_ _147_ VGND VGND VPWR VPWR _170_ sky130_fd_sc_hd__nor2_1
XFILLER_25_52 VGND VGND VPWR VPWR sky130_fd_sc_hd__fill_1
X_401_ clknet_2_3__leaf_clk _097_ net60 VGND VGND VPWR VPWR net33 sky130_fd_sc_hd__dfrtp_1
X_194_ net44 VGND VGND VPWR VPWR _128_ sky130_fd_sc_hd__inv_2
X_332_ net98 net41 VGND VGND VPWR VPWR _123_ sky130_fd_sc_hd__or2_1
XTAP_TAPCELL_ROW_19_146 VGND VPWR sky130_fd_sc_hd__tapvpwrvgnd_1
XFILLER_17_162 VGND VGND VPWR VPWR sky130_fd_sc_hd__decap_6
XTAP_TAPCELL_ROW_33_193 VGND VPWR sky130_fd_sc_hd__tapvpwrvgnd_1
XFILLER_23_187 VGND VGND VPWR VPWR sky130_fd_sc_hd__fill_1
XFILLER_14_121 VPWR VGND VPWR VGND sky130_ef_sc_hd__decap_12
X_246_ u_sar_core.state_q\[1\] net43 u_sar_core.state_q\[3\] VGND VGND VPWR VPWR _154_
+ sky130_fd_sc_hd__o21ba_1
X_315_ conv_channel_w\[2\] net73 _011_ VGND VGND VPWR VPWR _105_ sky130_fd_sc_hd__mux2_1
XTAP_TAPCELL_ROW_30_185 VGND VPWR sky130_fd_sc_hd__tapvpwrvgnd_1
XTAP_TAPCELL_ROW_21_152 VGND VPWR sky130_fd_sc_hd__tapvpwrvgnd_1
XFILLER_11_113 VGND VGND VPWR VPWR sky130_fd_sc_hd__fill_1
XFILLER_7_128 VPWR VGND VPWR VGND sky130_ef_sc_hd__decap_12
XFILLER_22_97 VGND VGND VPWR VPWR sky130_fd_sc_hd__decap_3
X_229_ u_spi.tx_shift_q\[11\] u_spi.tx_snapshot_q\[11\] net38 VGND VGND VPWR VPWR
+ _014_ sky130_fd_sc_hd__mux2_1
XTAP_TAPCELL_ROW_35_200 VGND VPWR sky130_fd_sc_hd__tapvpwrvgnd_1
XFILLER_33_74 VPWR VGND VPWR VGND sky130_ef_sc_hd__decap_12
XFILLER_31_219 VGND VGND VPWR VPWR sky130_fd_sc_hd__fill_1
XFILLER_17_53 VGND VGND VPWR VPWR sky130_fd_sc_hd__decap_3
XFILLER_17_31 VGND VGND VPWR VPWR sky130_fd_sc_hd__fill_2
Xhold4 _104_ VGND VGND VPWR VPWR net70 sky130_fd_sc_hd__dlygate4sd3_1
XFILLER_12_7 VPWR VGND VPWR VGND sky130_ef_sc_hd__decap_12
XPHY_EDGE_ROW_26_Right_26 VGND VGND VPWR VPWR sky130_fd_sc_hd__decap_3
XPHY_EDGE_ROW_17_Right_17 VGND VGND VPWR VPWR sky130_fd_sc_hd__decap_3
XFILLER_13_208 VPWR VGND VPWR VGND sky130_ef_sc_hd__decap_12
XPHY_EDGE_ROW_35_Right_35 VGND VGND VPWR VPWR sky130_fd_sc_hd__decap_3
X_477_ clknet_2_1__leaf_clk _001_ net58 VGND VGND VPWR VPWR net12 sky130_fd_sc_hd__dfrtp_1
XFILLER_26_130 VGND VGND VPWR VPWR sky130_fd_sc_hd__decap_6
X_400_ clknet_2_3__leaf_clk _096_ net60 VGND VGND VPWR VPWR net32 sky130_fd_sc_hd__dfrtp_1
XFILLER_25_86 VGND VGND VPWR VPWR sky130_fd_sc_hd__decap_4
XFILLER_25_31 VGND VGND VPWR VPWR sky130_fd_sc_hd__decap_6
X_262_ _130_ _167_ _168_ _155_ VGND VGND VPWR VPWR _169_ sky130_fd_sc_hd__and4bb_1
X_331_ net77 net9 net37 VGND VGND VPWR VPWR _122_ sky130_fd_sc_hd__mux2_1
XTAP_TAPCELL_ROW_33_194 VGND VPWR sky130_fd_sc_hd__tapvpwrvgnd_1
XFILLER_23_133 VGND VGND VPWR VPWR sky130_fd_sc_hd__fill_2
XFILLER_23_111 VGND VGND VPWR VPWR sky130_fd_sc_hd__fill_1
XFILLER_11_55 VGND VGND VPWR VPWR sky130_fd_sc_hd__fill_1
XFILLER_36_41 VGND VGND VPWR VPWR sky130_fd_sc_hd__decap_4
X_245_ u_sar_core.state_q\[3\] net43 VGND VGND VPWR VPWR _153_ sky130_fd_sc_hd__nand2b_2
XTAP_TAPCELL_ROW_24_161 VGND VPWR sky130_fd_sc_hd__tapvpwrvgnd_1
XFILLER_14_133 VGND VGND VPWR VPWR sky130_fd_sc_hd__decap_6
X_314_ conv_channel_w\[1\] net69 _011_ VGND VGND VPWR VPWR _104_ sky130_fd_sc_hd__mux2_1
XFILLER_34_217 VGND VGND VPWR VPWR sky130_fd_sc_hd__decap_3
XTAP_TAPCELL_ROW_21_153 VGND VPWR sky130_fd_sc_hd__tapvpwrvgnd_1
XTAP_TAPCELL_ROW_12_120 VGND VPWR sky130_fd_sc_hd__tapvpwrvgnd_1
XFILLER_11_169 VGND VGND VPWR VPWR sky130_fd_sc_hd__decap_8
XFILLER_11_125 VGND VGND VPWR VPWR sky130_fd_sc_hd__fill_2
XFILLER_0_3 VPWR VGND VPWR VGND sky130_ef_sc_hd__decap_12
XTAP_TAPCELL_ROW_35_201 VGND VPWR sky130_fd_sc_hd__tapvpwrvgnd_1
XFILLER_33_3 VPWR VGND VPWR VGND sky130_ef_sc_hd__decap_12
XFILLER_25_206 VGND VGND VPWR VPWR sky130_fd_sc_hd__decap_8
X_228_ u_spi.tx_shift_q\[10\] u_spi.tx_snapshot_q\[10\] net38 VGND VGND VPWR VPWR
+ _013_ sky130_fd_sc_hd__mux2_1
XFILLER_33_86 VPWR VGND VPWR VGND sky130_ef_sc_hd__decap_12
Xhold5 u_spi.channel_sync_q\[0\] VGND VGND VPWR VPWR net71 sky130_fd_sc_hd__dlygate4sd3_1
XFILLER_0_113 VGND VGND VPWR VPWR sky130_fd_sc_hd__fill_2
XFILLER_5_35 VPWR VGND VPWR VGND sky130_ef_sc_hd__decap_12
XFILLER_5_57 VGND VGND VPWR VPWR sky130_fd_sc_hd__decap_8
XFILLER_30_76 VGND VGND VPWR VPWR sky130_fd_sc_hd__fill_1
X_476_ clknet_2_0__leaf_clk _000_ net52 VGND VGND VPWR VPWR net11 sky130_fd_sc_hd__dfrtp_1
X_261_ net44 _134_ _141_ VGND VGND VPWR VPWR _168_ sky130_fd_sc_hd__or3b_1
X_330_ net99 net8 net37 VGND VGND VPWR VPWR _121_ sky130_fd_sc_hd__mux2_1
X_459_ _063_ _020_ _062_ VGND VGND VPWR VPWR u_spi.tx_shift_q\[3\] sky130_fd_sc_hd__dfrtp_1
XTAP_TAPCELL_ROW_33_195 VGND VPWR sky130_fd_sc_hd__tapvpwrvgnd_1
XFILLER_23_101 VGND VGND VPWR VPWR sky130_fd_sc_hd__fill_2
XTAP_TAPCELL_ROW_24_162 VGND VPWR sky130_fd_sc_hd__tapvpwrvgnd_1
X_244_ net44 _129_ _133_ VGND VGND VPWR VPWR _152_ sky130_fd_sc_hd__or3b_1
X_313_ conv_channel_w\[0\] net71 _011_ VGND VGND VPWR VPWR _103_ sky130_fd_sc_hd__mux2_1
XFILLER_20_137 VGND VGND VPWR VPWR sky130_fd_sc_hd__decap_3
XFILLER_11_148 VGND VGND VPWR VPWR sky130_fd_sc_hd__fill_1
XTAP_TAPCELL_ROW_35_202 VGND VPWR sky130_fd_sc_hd__tapvpwrvgnd_1
XFILLER_26_3 VPWR VGND VPWR VGND sky130_ef_sc_hd__decap_12
X_227_ u_spi.tx_shift_q\[9\] u_spi.tx_snapshot_q\[9\] net39 VGND VGND VPWR VPWR _012_
+ sky130_fd_sc_hd__mux2_1
XTAP_TAPCELL_ROW_12_121 VGND VPWR sky130_fd_sc_hd__tapvpwrvgnd_1
XFILLER_33_98 VGND VGND VPWR VPWR sky130_fd_sc_hd__decap_6
XFILLER_33_65 VGND VGND VPWR VPWR sky130_fd_sc_hd__fill_1
XPHY_EDGE_ROW_9_Left_46 VGND VGND VPWR VPWR sky130_fd_sc_hd__decap_3
Xhold6 _103_ VGND VGND VPWR VPWR net72 sky130_fd_sc_hd__dlygate4sd3_1
XPHY_EDGE_ROW_3_Right_3 VGND VGND VPWR VPWR sky130_fd_sc_hd__decap_3
XFILLER_0_169 VGND VGND VPWR VPWR sky130_fd_sc_hd__fill_2
XFILLER_5_47 VGND VGND VPWR VPWR sky130_fd_sc_hd__decap_8
XFILLER_30_55 VGND VGND VPWR VPWR sky130_fd_sc_hd__fill_2
XFILLER_35_110 VGND VGND VPWR VPWR sky130_fd_sc_hd__fill_2
X_475_ clknet_2_1__leaf_clk net78 net54 VGND VGND VPWR VPWR net9 sky130_fd_sc_hd__dfrtp_1
XFILLER_26_110 VGND VGND VPWR VPWR sky130_fd_sc_hd__fill_1
XFILLER_25_44 VGND VGND VPWR VPWR sky130_fd_sc_hd__decap_8
X_260_ _133_ _136_ _141_ _146_ _135_ VGND VGND VPWR VPWR _167_ sky130_fd_sc_hd__o2111ai_2
XFILLER_2_209 VGND VGND VPWR VPWR sky130_fd_sc_hd__decap_8
X_458_ _061_ _019_ _060_ VGND VGND VPWR VPWR u_spi.tx_shift_q\[2\] sky130_fd_sc_hd__dfrtp_1
XPHY_EDGE_ROW_22_Left_59 VGND VGND VPWR VPWR sky130_fd_sc_hd__decap_3
XFILLER_2_15 VPWR VGND VPWR VGND sky130_ef_sc_hd__decap_12
X_389_ net48 VGND VGND VPWR VPWR _083_ sky130_fd_sc_hd__inv_2
XFILLER_23_113 VPWR VGND VPWR VGND sky130_ef_sc_hd__decap_12
XFILLER_36_98 VGND VGND VPWR VPWR sky130_fd_sc_hd__decap_3
XTAP_TAPCELL_ROW_24_163 VGND VPWR sky130_fd_sc_hd__tapvpwrvgnd_1
X_243_ u_sar_core.state_q\[1\] _133_ VGND VGND VPWR VPWR _151_ sky130_fd_sc_hd__nand2_1
XFILLER_14_146 VPWR VGND VPWR VGND sky130_ef_sc_hd__decap_12
X_312_ u_spi.start_toggle_q _191_ VGND VGND VPWR VPWR _102_ sky130_fd_sc_hd__xor2_1
XTAP_TAPCELL_ROW_15_130 VGND VPWR sky130_fd_sc_hd__tapvpwrvgnd_1
XFILLER_22_23 VGND VGND VPWR VPWR sky130_fd_sc_hd__decap_4
XPHY_EDGE_ROW_25_Left_62 VGND VGND VPWR VPWR sky130_fd_sc_hd__decap_3
X_226_ u_spi.tx_shift_q\[8\] u_spi.tx_snapshot_q\[8\] net39 VGND VGND VPWR VPWR _026_
+ sky130_fd_sc_hd__mux2_1
XTAP_TAPCELL_ROW_12_122 VGND VPWR sky130_fd_sc_hd__tapvpwrvgnd_1
XFILLER_16_219 VGND VGND VPWR VPWR sky130_fd_sc_hd__fill_1
XFILLER_33_55 VGND VGND VPWR VPWR sky130_fd_sc_hd__fill_1
XFILLER_3_167 VGND VGND VPWR VPWR sky130_fd_sc_hd__fill_1
XFILLER_3_178 VPWR VGND VPWR VGND sky130_ef_sc_hd__decap_12
Xhold7 u_spi.channel_sync_q\[2\] VGND VGND VPWR VPWR net73 sky130_fd_sc_hd__dlygate4sd3_1
X_209_ _138_ u_spi.bit_count_q\[3\] u_spi.bit_count_q\[2\] VGND VGND VPWR VPWR _139_
+ sky130_fd_sc_hd__nor3b_1
XFILLER_0_70 VPWR VGND VPWR VGND sky130_ef_sc_hd__decap_12
X_491_ u_spi.miso_bit _193_ VGND VGND VPWR VPWR miso sky130_fd_sc_hd__ebufn_8
XFILLER_0_126 VGND VGND VPWR VPWR sky130_fd_sc_hd__decap_3
XPHY_EDGE_ROW_22_Right_22 VGND VGND VPWR VPWR sky130_fd_sc_hd__decap_3
XPHY_EDGE_ROW_13_Right_13 VGND VGND VPWR VPWR sky130_fd_sc_hd__decap_3
XPHY_EDGE_ROW_31_Right_31 VGND VGND VPWR VPWR sky130_fd_sc_hd__decap_3
XFILLER_30_89 VGND VGND VPWR VPWR sky130_fd_sc_hd__fill_1
XFILLER_5_218 VGND VGND VPWR VPWR sky130_fd_sc_hd__fill_2
XFILLER_29_141 VGND VGND VPWR VPWR sky130_fd_sc_hd__decap_6
X_474_ clknet_2_1__leaf_clk net100 net54 VGND VGND VPWR VPWR net8 sky130_fd_sc_hd__dfrtp_1
XFILLER_35_122 VGND VGND VPWR VPWR sky130_fd_sc_hd__decap_3
XFILLER_6_91 VGND VGND VPWR VPWR sky130_fd_sc_hd__fill_1
XTAP_TAPCELL_ROW_27_172 VGND VPWR sky130_fd_sc_hd__tapvpwrvgnd_1
XFILLER_17_111 VGND VGND VPWR VPWR sky130_fd_sc_hd__fill_1
XFILLER_2_27 VGND VGND VPWR VPWR sky130_fd_sc_hd__fill_1
XFILLER_23_169 VPWR VGND VPWR VGND sky130_ef_sc_hd__decap_12
XFILLER_23_125 VGND VGND VPWR VPWR sky130_fd_sc_hd__decap_8
X_457_ _059_ _018_ _058_ VGND VGND VPWR VPWR u_spi.tx_shift_q\[1\] sky130_fd_sc_hd__dfrtp_1
X_388_ net48 VGND VGND VPWR VPWR _081_ sky130_fd_sc_hd__inv_2
XFILLER_36_66 VGND VGND VPWR VPWR sky130_fd_sc_hd__fill_2
XFILLER_36_55 VGND VGND VPWR VPWR sky130_fd_sc_hd__fill_1
XTAP_TAPCELL_ROW_24_164 VGND VPWR sky130_fd_sc_hd__tapvpwrvgnd_1
X_242_ _149_ _150_ net37 VGND VGND VPWR VPWR _000_ sky130_fd_sc_hd__o21a_1
X_311_ net47 _137_ _139_ _190_ VGND VGND VPWR VPWR _191_ sky130_fd_sc_hd__and4_2
XTAP_TAPCELL_ROW_15_131 VGND VPWR sky130_fd_sc_hd__tapvpwrvgnd_1
XFILLER_28_217 VGND VGND VPWR VPWR sky130_fd_sc_hd__decap_3
XFILLER_22_79 VGND VGND VPWR VPWR sky130_fd_sc_hd__decap_4
XFILLER_34_209 VGND VGND VPWR VPWR sky130_fd_sc_hd__decap_8
X_225_ u_spi.tx_shift_q\[7\] u_spi.tx_snapshot_q\[7\] net39 VGND VGND VPWR VPWR _025_
+ sky130_fd_sc_hd__mux2_1
XFILLER_8_15 VPWR VGND VPWR VGND sky130_ef_sc_hd__decap_12
Xhold8 _105_ VGND VGND VPWR VPWR net74 sky130_fd_sc_hd__dlygate4sd3_1
XFILLER_3_113 VGND VGND VPWR VPWR sky130_fd_sc_hd__fill_1
XFILLER_31_3 VPWR VGND VPWR VGND sky130_ef_sc_hd__decap_12
X_208_ _027_ u_spi.bit_count_q\[4\] u_spi.bit_count_q\[1\] VGND VGND VPWR VPWR _138_
+ sky130_fd_sc_hd__or3_1
XFILLER_0_82 VGND VGND VPWR VPWR sky130_fd_sc_hd__fill_2
X_490_ clknet_2_2__leaf_clk _127_ net59 VGND VGND VPWR VPWR u_sar_core.state_q\[3\]
+ sky130_fd_sc_hd__dfrtp_4
Xclkbuf_2_3__f_clk clknet_0_clk VGND VGND VPWR VPWR clknet_2_3__leaf_clk sky130_fd_sc_hd__clkbuf_16
XFILLER_30_68 VGND VGND VPWR VPWR sky130_fd_sc_hd__decap_8
X_473_ clknet_2_0__leaf_clk net76 net53 VGND VGND VPWR VPWR net7 sky130_fd_sc_hd__dfrtp_1
XFILLER_25_57 VGND VGND VPWR VPWR sky130_fd_sc_hd__decap_4
XFILLER_9_3 VGND VGND VPWR VPWR sky130_fd_sc_hd__decap_8
XTAP_TAPCELL_ROW_27_173 VGND VPWR sky130_fd_sc_hd__tapvpwrvgnd_1
XTAP_TAPCELL_ROW_18_140 VGND VPWR sky130_fd_sc_hd__tapvpwrvgnd_1
X_387_ net48 VGND VGND VPWR VPWR _079_ sky130_fd_sc_hd__inv_2
X_456_ _057_ net35 net55 VGND VGND VPWR VPWR u_spi.tx_snapshot_q\[15\] sky130_fd_sc_hd__dfrtp_1
X_310_ u_spi.start_bit_w u_spi.sgl_bit_w net3 VGND VGND VPWR VPWR _190_ sky130_fd_sc_hd__and3_1
XFILLER_11_26 VGND VGND VPWR VPWR sky130_fd_sc_hd__fill_1
XFILLER_22_192 VGND VGND VPWR VPWR sky130_fd_sc_hd__decap_4
X_241_ net11 net1 net40 VGND VGND VPWR VPWR _150_ sky130_fd_sc_hd__mux2_1
XTAP_TAPCELL_ROW_15_132 VGND VPWR sky130_fd_sc_hd__tapvpwrvgnd_1
X_439_ net49 _031_ _041_ VGND VGND VPWR VPWR u_spi.bit_count_q\[4\] sky130_fd_sc_hd__dfrtp_1
X_224_ u_spi.tx_shift_q\[6\] u_spi.tx_snapshot_q\[6\] net39 VGND VGND VPWR VPWR _024_
+ sky130_fd_sc_hd__mux2_1
XFILLER_19_207 VPWR VGND VPWR VGND sky130_ef_sc_hd__decap_12
XFILLER_6_100 VGND VGND VPWR VPWR sky130_fd_sc_hd__fill_2
XTAP_TAPCELL_ROW_6_100 VGND VPWR sky130_fd_sc_hd__tapvpwrvgnd_1
XFILLER_6_166 VPWR VGND VPWR VGND sky130_ef_sc_hd__decap_12
XFILLER_8_27 VGND VGND VPWR VPWR sky130_fd_sc_hd__fill_1
XFILLER_17_69 VGND VGND VPWR VPWR sky130_fd_sc_hd__decap_6
Xhold9 conv_channel_w\[0\] VGND VGND VPWR VPWR net75 sky130_fd_sc_hd__dlygate4sd3_1
XFILLER_3_169 VGND VGND VPWR VPWR sky130_fd_sc_hd__decap_6
XFILLER_24_3 VPWR VGND VPWR VGND sky130_ef_sc_hd__decap_12
X_207_ _137_ VGND VGND VPWR VPWR net6 sky130_fd_sc_hd__inv_2
XFILLER_28_57 VGND VGND VPWR VPWR sky130_fd_sc_hd__fill_1
XFILLER_28_35 VGND VGND VPWR VPWR sky130_fd_sc_hd__fill_1
XFILLER_8_206 VPWR VGND VPWR VGND sky130_ef_sc_hd__decap_12
XFILLER_14_15 VPWR VGND VPWR VGND sky130_ef_sc_hd__decap_12
XPHY_EDGE_ROW_7_Right_7 VGND VGND VPWR VPWR sky130_fd_sc_hd__decap_3
X_472_ net48 _119_ _088_ VGND VGND VPWR VPWR u_spi.cmd_err_q sky130_fd_sc_hd__dfrtp_1
XFILLER_6_82 VGND VGND VPWR VPWR sky130_fd_sc_hd__fill_2
XFILLER_32_149 VPWR VGND VPWR VGND sky130_ef_sc_hd__decap_12
XTAP_TAPCELL_ROW_27_174 VGND VPWR sky130_fd_sc_hd__tapvpwrvgnd_1
X_386_ net48 VGND VGND VPWR VPWR _077_ sky130_fd_sc_hd__inv_2
XFILLER_17_179 VGND VGND VPWR VPWR sky130_fd_sc_hd__decap_8
XFILLER_17_146 VGND VGND VPWR VPWR sky130_fd_sc_hd__fill_1
XFILLER_2_29 VGND VGND VPWR VPWR sky130_fd_sc_hd__fill_2
X_455_ _056_ net6 net54 VGND VGND VPWR VPWR u_spi.tx_snapshot_q\[14\] sky130_fd_sc_hd__dfrtp_1
XFILLER_31_182 VGND VGND VPWR VPWR sky130_fd_sc_hd__fill_1
XTAP_TAPCELL_ROW_18_141 VGND VPWR sky130_fd_sc_hd__tapvpwrvgnd_1
X_240_ _147_ _128_ u_sar_core.state_q\[1\] VGND VGND VPWR VPWR _149_ sky130_fd_sc_hd__and3b_1
X_369_ net66 VGND VGND VPWR VPWR _049_ sky130_fd_sc_hd__inv_2
XFILLER_13_182 VGND VGND VPWR VPWR sky130_fd_sc_hd__fill_1
X_438_ net48 _030_ _040_ VGND VGND VPWR VPWR u_spi.bit_count_q\[3\] sky130_fd_sc_hd__dfrtp_1
X_223_ u_spi.tx_shift_q\[5\] u_spi.tx_snapshot_q\[5\] net39 VGND VGND VPWR VPWR _023_
+ sky130_fd_sc_hd__mux2_1
XFILLER_19_219 VGND VGND VPWR VPWR sky130_fd_sc_hd__fill_1
XTAP_TAPCELL_ROW_6_101 VGND VPWR sky130_fd_sc_hd__tapvpwrvgnd_1
XFILLER_10_141 VGND VGND VPWR VPWR sky130_fd_sc_hd__decap_4
XFILLER_10_174 VGND VGND VPWR VPWR sky130_fd_sc_hd__fill_2
XFILLER_17_48 VGND VGND VPWR VPWR sky130_fd_sc_hd__fill_2
XFILLER_3_159 VGND VGND VPWR VPWR sky130_fd_sc_hd__decap_8
XPHY_EDGE_ROW_29_Left_66 VGND VGND VPWR VPWR sky130_fd_sc_hd__decap_3
X_206_ net44 _135_ VGND VGND VPWR VPWR _137_ sky130_fd_sc_hd__nor2_1
XFILLER_28_69 VGND VGND VPWR VPWR sky130_fd_sc_hd__decap_6
XFILLER_8_218 VGND VGND VPWR VPWR sky130_fd_sc_hd__fill_2
XFILLER_30_15 VPWR VGND VPWR VGND sky130_ef_sc_hd__decap_12
XFILLER_29_166 VGND VGND VPWR VPWR sky130_fd_sc_hd__fill_2
XFILLER_29_111 VGND VGND VPWR VPWR sky130_fd_sc_hd__fill_1
XFILLER_14_27 VGND VGND VPWR VPWR sky130_fd_sc_hd__fill_1
X_471_ _087_ _017_ _086_ VGND VGND VPWR VPWR u_spi.tx_shift_q\[15\] sky130_fd_sc_hd__dfrtp_1
XFILLER_34_191 VGND VGND VPWR VPWR sky130_fd_sc_hd__decap_4
XFILLER_26_136 VGND VGND VPWR VPWR sky130_fd_sc_hd__fill_1
XPHY_EDGE_ROW_16_Left_53 VGND VGND VPWR VPWR sky130_fd_sc_hd__decap_3
XFILLER_6_61 VPWR VGND VPWR VGND sky130_ef_sc_hd__decap_12
X_385_ net5 VGND VGND VPWR VPWR _075_ sky130_fd_sc_hd__inv_2
XFILLER_17_169 VGND VGND VPWR VPWR sky130_fd_sc_hd__decap_4
XTAP_TAPCELL_ROW_2_84 VGND VPWR sky130_fd_sc_hd__tapvpwrvgnd_1
XFILLER_1_202 VPWR VGND VPWR VGND sky130_ef_sc_hd__decap_12
X_454_ _055_ net21 net55 VGND VGND VPWR VPWR u_spi.tx_snapshot_q\[13\] sky130_fd_sc_hd__dfrtp_1
XFILLER_23_139 VGND VGND VPWR VPWR sky130_fd_sc_hd__decap_6
XTAP_TAPCELL_ROW_18_142 VGND VPWR sky130_fd_sc_hd__tapvpwrvgnd_1
XFILLER_14_139 VGND VGND VPWR VPWR sky130_fd_sc_hd__fill_1
XPHY_EDGE_ROW_1_Left_38 VGND VGND VPWR VPWR sky130_fd_sc_hd__decap_3
XTAP_TAPCELL_ROW_9_110 VGND VPWR sky130_fd_sc_hd__tapvpwrvgnd_1
X_368_ net66 VGND VGND VPWR VPWR _048_ sky130_fd_sc_hd__inv_2
XFILLER_28_209 VGND VGND VPWR VPWR sky130_fd_sc_hd__decap_8
X_299_ net102 net90 net41 VGND VGND VPWR VPWR _091_ sky130_fd_sc_hd__mux2_1
XFILLER_20_109 VGND VGND VPWR VPWR sky130_fd_sc_hd__decap_8
X_437_ net48 _029_ _039_ VGND VGND VPWR VPWR u_spi.bit_count_q\[2\] sky130_fd_sc_hd__dfrtp_1
XFILLER_9_121 VPWR VGND VPWR VGND sky130_ef_sc_hd__decap_12
XFILLER_9_154 VPWR VGND VPWR VGND sky130_ef_sc_hd__decap_12
XPHY_EDGE_ROW_29_Right_29 VGND VGND VPWR VPWR sky130_fd_sc_hd__decap_3
XFILLER_22_27 VGND VGND VPWR VPWR sky130_fd_sc_hd__fill_1
X_222_ u_spi.tx_shift_q\[4\] u_spi.tx_snapshot_q\[4\] net38 VGND VGND VPWR VPWR _022_
+ sky130_fd_sc_hd__mux2_1
XFILLER_19_7 VGND VGND VPWR VPWR sky130_fd_sc_hd__decap_8
XFILLER_8_29 VPWR VGND VPWR VGND sky130_ef_sc_hd__decap_12
XFILLER_10_120 VPWR VGND VPWR VGND sky130_ef_sc_hd__decap_12
XFILLER_10_197 VGND VGND VPWR VPWR sky130_fd_sc_hd__decap_3
XFILLER_33_15 VPWR VGND VPWR VGND sky130_ef_sc_hd__decap_12
XFILLER_23_70 VGND VGND VPWR VPWR sky130_fd_sc_hd__decap_4
X_205_ net44 u_sar_core.state_q\[1\] VGND VGND VPWR VPWR _136_ sky130_fd_sc_hd__or2_2
XPHY_EDGE_ROW_4_Left_41 VGND VGND VPWR VPWR sky130_fd_sc_hd__decap_3
XFILLER_0_41 VPWR VGND VPWR VGND sky130_ef_sc_hd__decap_12
XPHY_EDGE_ROW_30_Left_67 VGND VGND VPWR VPWR sky130_fd_sc_hd__decap_3
XFILLER_28_15 VPWR VGND VPWR VGND sky130_ef_sc_hd__decap_12
XFILLER_0_119 VGND VGND VPWR VPWR sky130_fd_sc_hd__decap_3
XFILLER_34_80 VGND VGND VPWR VPWR sky130_fd_sc_hd__decap_4
XTAP_TAPCELL_ROW_5_95 VGND VPWR sky130_fd_sc_hd__tapvpwrvgnd_1
XFILLER_30_27 VGND VGND VPWR VPWR sky130_fd_sc_hd__fill_1
X_470_ _085_ _016_ _084_ VGND VGND VPWR VPWR u_spi.tx_shift_q\[14\] sky130_fd_sc_hd__dfrtp_1
XFILLER_6_73 VGND VGND VPWR VPWR sky130_fd_sc_hd__fill_1
X_384_ net5 VGND VGND VPWR VPWR _073_ sky130_fd_sc_hd__inv_2
XFILLER_1_214 VGND VGND VPWR VPWR sky130_fd_sc_hd__decap_6
X_453_ _054_ net24 net55 VGND VGND VPWR VPWR u_spi.tx_snapshot_q\[12\] sky130_fd_sc_hd__dfrtp_1
XPHY_EDGE_ROW_33_Left_70 VGND VGND VPWR VPWR sky130_fd_sc_hd__decap_3
XFILLER_31_140 VPWR VGND VPWR VGND sky130_ef_sc_hd__decap_12
XTAP_TAPCELL_ROW_18_143 VGND VPWR sky130_fd_sc_hd__tapvpwrvgnd_1
XTAP_TAPCELL_ROW_2_85 VGND VPWR sky130_fd_sc_hd__tapvpwrvgnd_1
XFILLER_36_15 VPWR VGND VPWR VGND sky130_ef_sc_hd__decap_12
XTAP_TAPCELL_ROW_32_190 VGND VPWR sky130_fd_sc_hd__tapvpwrvgnd_1
XFILLER_7_3 VPWR VGND VPWR VGND sky130_ef_sc_hd__decap_12
XTAP_TAPCELL_ROW_9_111 VGND VPWR sky130_fd_sc_hd__tapvpwrvgnd_1
X_367_ net66 VGND VGND VPWR VPWR _047_ sky130_fd_sc_hd__inv_2
X_298_ net101 net94 net41 VGND VGND VPWR VPWR _090_ sky130_fd_sc_hd__mux2_1
X_436_ net49 _028_ _038_ VGND VGND VPWR VPWR u_spi.bit_count_q\[1\] sky130_fd_sc_hd__dfrtp_1
XFILLER_9_111 VGND VGND VPWR VPWR sky130_fd_sc_hd__fill_1
XFILLER_9_133 VPWR VGND VPWR VGND sky130_ef_sc_hd__decap_12
XFILLER_9_166 VGND VGND VPWR VPWR sky130_fd_sc_hd__fill_2
X_221_ u_spi.tx_shift_q\[3\] u_spi.tx_snapshot_q\[3\] net38 VGND VGND VPWR VPWR _021_
+ sky130_fd_sc_hd__mux2_1
XFILLER_10_132 VGND VGND VPWR VPWR sky130_fd_sc_hd__decap_8
XFILLER_17_39 VGND VGND VPWR VPWR sky130_fd_sc_hd__decap_3
X_419_ clknet_2_0__leaf_clk u_spi.req_channel_q\[1\] net53 VGND VGND VPWR VPWR u_spi.channel_sync_q\[1\]
+ sky130_fd_sc_hd__dfrtp_1
XFILLER_33_27 VPWR VGND VPWR VGND sky130_ef_sc_hd__decap_12
X_204_ u_sar_core.state_q\[1\] net43 u_sar_core.state_q\[3\] VGND VGND VPWR VPWR _135_
+ sky130_fd_sc_hd__or3_2
XFILLER_21_205 VPWR VGND VPWR VGND sky130_ef_sc_hd__decap_12
XFILLER_0_53 VGND VGND VPWR VPWR sky130_fd_sc_hd__decap_3
XFILLER_9_95 VGND VGND VPWR VPWR sky130_fd_sc_hd__decap_8
XFILLER_28_27 VGND VGND VPWR VPWR sky130_fd_sc_hd__fill_1
XFILLER_18_60 VGND VGND VPWR VPWR sky130_fd_sc_hd__fill_2
XTAP_TAPCELL_ROW_5_96 VGND VPWR sky130_fd_sc_hd__tapvpwrvgnd_1
XFILLER_14_29 VPWR VGND VPWR VGND sky130_ef_sc_hd__decap_12
XFILLER_6_85 VGND VGND VPWR VPWR sky130_fd_sc_hd__decap_6
X_383_ net49 VGND VGND VPWR VPWR _071_ sky130_fd_sc_hd__inv_2
X_452_ _053_ net23 net57 VGND VGND VPWR VPWR u_spi.tx_snapshot_q\[11\] sky130_fd_sc_hd__dfrtp_1
XFILLER_31_152 VPWR VGND VPWR VGND sky130_ef_sc_hd__decap_12
XFILLER_15_72 VGND VGND VPWR VPWR sky130_fd_sc_hd__decap_3
XTAP_TAPCELL_ROW_2_86 VGND VPWR sky130_fd_sc_hd__tapvpwrvgnd_1
XFILLER_36_49 VGND VGND VPWR VPWR sky130_fd_sc_hd__decap_6
XFILLER_36_27 VGND VGND VPWR VPWR sky130_fd_sc_hd__fill_1
XTAP_TAPCELL_ROW_32_191 VGND VPWR sky130_fd_sc_hd__tapvpwrvgnd_1
X_366_ net66 VGND VGND VPWR VPWR _046_ sky130_fd_sc_hd__inv_2
X_297_ net82 net81 net41 VGND VGND VPWR VPWR _089_ sky130_fd_sc_hd__mux2_1
X_435_ net48 _027_ _037_ VGND VGND VPWR VPWR u_spi.bit_count_q\[0\] sky130_fd_sc_hd__dfrtp_1
XFILLER_9_145 VGND VGND VPWR VPWR sky130_fd_sc_hd__fill_2
XFILLER_9_178 VPWR VGND VPWR VGND sky130_ef_sc_hd__decap_12
XFILLER_22_29 VGND VGND VPWR VPWR sky130_fd_sc_hd__decap_8
X_220_ u_spi.tx_shift_q\[2\] u_spi.tx_snapshot_q\[2\] net38 VGND VGND VPWR VPWR _020_
+ sky130_fd_sc_hd__mux2_1
XTAP_TAPCELL_ROW_20_150 VGND VPWR sky130_fd_sc_hd__tapvpwrvgnd_1
XFILLER_6_137 VGND VGND VPWR VPWR sky130_fd_sc_hd__decap_3
X_349_ net46 net60 VGND VGND VPWR VPWR _062_ sky130_fd_sc_hd__and2_1
X_418_ clknet_2_0__leaf_clk u_spi.req_channel_q\[0\] net51 VGND VGND VPWR VPWR u_spi.channel_sync_q\[0\]
+ sky130_fd_sc_hd__dfrtp_1
XFILLER_33_39 VPWR VGND VPWR VGND sky130_ef_sc_hd__decap_12
XFILLER_15_203 VPWR VGND VPWR VGND sky130_ef_sc_hd__decap_12
XFILLER_30_206 VPWR VGND VPWR VGND sky130_ef_sc_hd__decap_12
X_203_ u_sar_core.state_q\[1\] net43 u_sar_core.state_q\[3\] VGND VGND VPWR VPWR _134_
+ sky130_fd_sc_hd__nor3_1
XFILLER_21_217 VGND VGND VPWR VPWR sky130_fd_sc_hd__decap_3
XFILLER_0_65 VGND VGND VPWR VPWR sky130_fd_sc_hd__fill_1
XFILLER_28_39 VPWR VGND VPWR VGND sky130_ef_sc_hd__decap_12
XFILLER_12_217 VGND VGND VPWR VPWR sky130_fd_sc_hd__decap_3
XFILLER_9_74 VGND VGND VPWR VPWR sky130_fd_sc_hd__fill_1
XFILLER_18_83 VGND VGND VPWR VPWR sky130_fd_sc_hd__fill_1
XTAP_TAPCELL_ROW_5_97 VGND VPWR sky130_fd_sc_hd__tapvpwrvgnd_1
XFILLER_15_3 VPWR VGND VPWR VGND sky130_ef_sc_hd__decap_12
XFILLER_29_147 VGND VGND VPWR VPWR sky130_fd_sc_hd__fill_1
XFILLER_28_180 VPWR VGND VPWR VGND sky130_ef_sc_hd__decap_12
XFILLER_34_150 VGND VGND VPWR VPWR sky130_fd_sc_hd__fill_1
X_382_ net49 VGND VGND VPWR VPWR _069_ sky130_fd_sc_hd__inv_2
X_451_ _052_ net22 net57 VGND VGND VPWR VPWR u_spi.tx_snapshot_q\[10\] sky130_fd_sc_hd__dfrtp_1
XTAP_TAPCELL_ROW_2_87 VGND VPWR sky130_fd_sc_hd__tapvpwrvgnd_1
XFILLER_31_164 VGND VGND VPWR VPWR sky130_fd_sc_hd__fill_1
XFILLER_14_109 VPWR VGND VPWR VGND sky130_ef_sc_hd__decap_12
XTAP_TAPCELL_ROW_32_192 VGND VPWR sky130_fd_sc_hd__tapvpwrvgnd_1
X_365_ net66 VGND VGND VPWR VPWR _045_ sky130_fd_sc_hd__inv_2
XFILLER_22_164 VGND VGND VPWR VPWR sky130_fd_sc_hd__decap_4
X_434_ clknet_2_1__leaf_clk _118_ net56 VGND VGND VPWR VPWR sar_result_w\[9\] sky130_fd_sc_hd__dfrtp_1
X_296_ u_spi.bit_count_q\[4\] _189_ VGND VGND VPWR VPWR _031_ sky130_fd_sc_hd__xnor2_1
XFILLER_3_65 VGND VGND VPWR VPWR sky130_fd_sc_hd__decap_4
XFILLER_12_85 VPWR VGND VPWR VGND sky130_ef_sc_hd__decap_12
XFILLER_12_41 VGND VGND VPWR VPWR sky130_fd_sc_hd__decap_3
X_279_ _180_ _181_ net37 VGND VGND VPWR VPWR _006_ sky130_fd_sc_hd__o21a_1
X_348_ net46 net62 VGND VGND VPWR VPWR _064_ sky130_fd_sc_hd__and2_1
XPHY_EDGE_ROW_25_Right_25 VGND VGND VPWR VPWR sky130_fd_sc_hd__decap_3
XPHY_EDGE_ROW_16_Right_16 VGND VGND VPWR VPWR sky130_fd_sc_hd__decap_3
X_417_ net50 _108_ net51 VGND VGND VPWR VPWR u_spi.req_channel_q\[2\] sky130_fd_sc_hd__dfrtp_1
XPHY_EDGE_ROW_34_Right_34 VGND VGND VPWR VPWR sky130_fd_sc_hd__decap_3
XFILLER_17_19 VPWR VGND VPWR VGND sky130_ef_sc_hd__decap_12
XFILLER_3_108 VGND VGND VPWR VPWR sky130_fd_sc_hd__decap_4
XFILLER_30_218 VGND VGND VPWR VPWR sky130_fd_sc_hd__fill_2
X_202_ net43 u_sar_core.state_q\[3\] VGND VGND VPWR VPWR _133_ sky130_fd_sc_hd__nor2_1
XFILLER_17_7 VPWR VGND VPWR VGND sky130_ef_sc_hd__decap_12
XFILLER_15_215 VGND VGND VPWR VPWR sky130_fd_sc_hd__decap_4
XFILLER_28_29 VGND VGND VPWR VPWR sky130_fd_sc_hd__decap_6
XFILLER_9_53 VGND VGND VPWR VPWR sky130_fd_sc_hd__decap_3
XFILLER_18_51 VGND VGND VPWR VPWR sky130_fd_sc_hd__decap_6
XPHY_EDGE_ROW_8_Left_45 VGND VGND VPWR VPWR sky130_fd_sc_hd__decap_3
XFILLER_34_94 VGND VGND VPWR VPWR sky130_fd_sc_hd__decap_8
XPHY_EDGE_ROW_2_Right_2 VGND VGND VPWR VPWR sky130_fd_sc_hd__decap_3
XFILLER_29_72 VGND VGND VPWR VPWR sky130_fd_sc_hd__decap_6
XFILLER_29_50 VGND VGND VPWR VPWR sky130_fd_sc_hd__fill_1
XFILLER_28_192 VGND VGND VPWR VPWR sky130_fd_sc_hd__decap_4
XFILLER_20_85 VPWR VGND VPWR VGND sky130_ef_sc_hd__decap_12
XFILLER_20_41 VPWR VGND VPWR VGND sky130_ef_sc_hd__decap_12
Xhold50 _099_ VGND VGND VPWR VPWR net116 sky130_fd_sc_hd__dlygate4sd3_1
XFILLER_34_195 VGND VGND VPWR VPWR sky130_fd_sc_hd__fill_1
XFILLER_19_181 VGND VGND VPWR VPWR sky130_fd_sc_hd__fill_2
X_381_ net49 VGND VGND VPWR VPWR _067_ sky130_fd_sc_hd__inv_2
X_450_ _051_ net34 net57 VGND VGND VPWR VPWR u_spi.tx_snapshot_q\[9\] sky130_fd_sc_hd__dfrtp_1
XFILLER_17_107 VGND VGND VPWR VPWR sky130_fd_sc_hd__decap_4
XFILLER_15_63 VGND VGND VPWR VPWR sky130_fd_sc_hd__fill_1
XFILLER_36_29 VPWR VGND VPWR VGND sky130_ef_sc_hd__decap_12
XFILLER_16_195 VGND VGND VPWR VPWR sky130_fd_sc_hd__fill_1
X_433_ clknet_2_3__leaf_clk net97 net60 VGND VGND VPWR VPWR sar_result_w\[8\] sky130_fd_sc_hd__dfrtp_1
X_364_ net66 VGND VGND VPWR VPWR _044_ sky130_fd_sc_hd__inv_2
XTAP_TAPCELL_ROW_23_160 VGND VPWR sky130_fd_sc_hd__tapvpwrvgnd_1
XPHY_EDGE_ROW_21_Left_58 VGND VGND VPWR VPWR sky130_fd_sc_hd__decap_3
X_295_ u_spi.bit_count_q\[3\] _188_ VGND VGND VPWR VPWR _030_ sky130_fd_sc_hd__xor2_1
XFILLER_3_55 VGND VGND VPWR VPWR sky130_fd_sc_hd__fill_1
XTAP_TAPCELL_ROW_12_119 VGND VPWR sky130_fd_sc_hd__tapvpwrvgnd_1
XFILLER_8_180 VPWR VGND VPWR VGND sky130_ef_sc_hd__decap_12
X_347_ net46 net62 VGND VGND VPWR VPWR _066_ sky130_fd_sc_hd__and2_1
X_278_ _136_ _153_ _160_ _169_ VGND VGND VPWR VPWR _181_ sky130_fd_sc_hd__a2bb2o_1
XFILLER_12_97 VPWR VGND VPWR VGND sky130_ef_sc_hd__decap_12
XFILLER_5_3 VPWR VGND VPWR VGND sky130_ef_sc_hd__decap_12
X_416_ net50 _107_ net51 VGND VGND VPWR VPWR u_spi.req_channel_q\[1\] sky130_fd_sc_hd__dfrtp_1
XFILLER_24_205 VPWR VGND VPWR VGND sky130_ef_sc_hd__decap_12
XFILLER_23_74 VGND VGND VPWR VPWR sky130_fd_sc_hd__fill_1
XFILLER_23_52 VGND VGND VPWR VPWR sky130_fd_sc_hd__decap_4
X_201_ net49 VGND VGND VPWR VPWR _059_ sky130_fd_sc_hd__inv_2
XFILLER_2_197 VPWR VGND VPWR VGND sky130_ef_sc_hd__decap_12
XPHY_EDGE_ROW_24_Left_61 VGND VGND VPWR VPWR sky130_fd_sc_hd__decap_3
XFILLER_9_21 VPWR VGND VPWR VGND sky130_ef_sc_hd__decap_12
XFILLER_18_85 VPWR VGND VPWR VGND sky130_ef_sc_hd__decap_12
Xhold40 net17 VGND VGND VPWR VPWR net106 sky130_fd_sc_hd__dlygate4sd3_1
XFILLER_20_97 VPWR VGND VPWR VGND sky130_ef_sc_hd__decap_12
XFILLER_20_53 VPWR VGND VPWR VGND sky130_ef_sc_hd__decap_12
Xhold51 u_spi.sync_toggle_q3 VGND VGND VPWR VPWR net117 sky130_fd_sc_hd__dlygate4sd3_1
XFILLER_26_119 VGND VGND VPWR VPWR sky130_fd_sc_hd__decap_3
XFILLER_6_33 VGND VGND VPWR VPWR sky130_fd_sc_hd__decap_8
Xoutput30 net30 VGND VGND VPWR VPWR result_data[5] sky130_fd_sc_hd__buf_2
X_380_ net49 VGND VGND VPWR VPWR _065_ sky130_fd_sc_hd__inv_2
Xoutput6 net6 VGND VGND VPWR VPWR busy sky130_fd_sc_hd__buf_2
XFILLER_31_122 VGND VGND VPWR VPWR sky130_fd_sc_hd__fill_1
XFILLER_31_100 VPWR VGND VPWR VGND sky130_ef_sc_hd__decap_12
XFILLER_16_141 VPWR VGND VPWR VGND sky130_ef_sc_hd__decap_12
.ends
